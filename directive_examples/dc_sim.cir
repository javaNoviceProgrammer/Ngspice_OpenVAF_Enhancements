* directive_demo DC sweep: V(out) = gain * V(in), gain = 0.5
.model dm directive_demo(gain=0.5)
vin in 0 dc 0
n1 in out dm
rload out 0 1k

.dc vin 0 2 0.05
.control
pre_osdi directive_demo.osdi
run
wrdata dc_result.txt v(in) v(out)
.endc
.end
