`include "disciplines.vams"
module tsa(a);
    inout a; electrical a;
    electrical gnd; ground gnd;
    parameter real R = 1000.0 from (0:inf);
    analog I(a, gnd) <+ V(a, gnd) / R;
endmodule
