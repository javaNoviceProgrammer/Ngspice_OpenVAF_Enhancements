`include "disciplines.vams"
module tsb(a);
    inout a; electrical a;
    ground gnd; electrical gnd;
    parameter real R = 1000.0 from (0:inf);
    analog I(a, gnd) <+ V(a, gnd) / R;
endmodule
