* Indirect branch assignment example: ideal op-amp unity-gain buffer (AC)
* Expected: 0 dB gain (flat), 0 deg phase across all frequencies (ideal,
* infinite bandwidth, zero output impedance).
.model amp opamp()
Namp1 out pin out amp
RL out 0 1k
Vin pin 0 DC 0 AC 1
.ac dec 20 1k 1G
.control
  pre_osdi OSDIFILE
  run
  wrdata RESULTFILE vdb(out) vp(out)
.endc
.end
