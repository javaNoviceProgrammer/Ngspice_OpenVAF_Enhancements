`include "disciplines.vams"
module nullarg(p,n); inout p,n; electrical p,n; parameter integer dir = +1; integer en = 1; real r;
analog begin @(cross(V(p,n) - 0.5, dir, , , en)) r = 1; @(above(V(p,n), , 1e-3)) r = 2; @(timer(0, , 1e-9, 1)) r = 3; I(p,n) <+ V(p,n); end endmodule
