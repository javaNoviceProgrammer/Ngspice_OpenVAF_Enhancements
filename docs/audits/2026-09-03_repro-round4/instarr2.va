`include "disciplines.vams"
module leaf(p,n); inout p,n; electrical p,n; parameter real g = 1e-3; analog I(p,n) <+ V(p,n)*g; endmodule
module instarr2(p,n); inout p,n; electrical p,n; leaf arr[0:3] (p,n); analog @(initial_step) $strobe("arr[2].g=%g", arr[2].g); endmodule
