`include "disciplines.vams"
module swn(p,n); inout p,n; electrical p,n; parameter integer sw = 1;
analog begin if (sw) V(p,n) <+ white_noise(1e-12,"wn"); else I(p,n) <+ white_noise(1e-12,"wn") + V(p,n)*1e-3; end endmodule
module swn9(p,n); inout p,n; electrical p,n; parameter integer sw = 1; swn #(.sw(sw), .$mfactor(9)) x(p,n); endmodule
module swfl(p,n); inout p,n; electrical p,n; parameter integer sw = 1;
analog begin if (sw) V(p,n) <+ flicker_noise(1e-12, 1.0, "fn"); else I(p,n) <+ V(p,n)*1e-3; end endmodule
