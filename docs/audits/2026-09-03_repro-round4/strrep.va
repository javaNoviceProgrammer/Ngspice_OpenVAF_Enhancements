`include "disciplines.vams"
module strrep(p,n);
inout p,n; electrical p,n;
parameter string default_name = "John Smith";
string myName = default_name;
string s1 = "hello\0world";
string names[1:3] = '{"first", "middle", "last"};
string paths[0:2][0:1] = '{ '{"dir1", "fileA"}, '{"dir2", "fileA"},'{"dir1","fileB"}};
string a, b, e = "";
integer i = 3, k;
integer neg[-2:2]; real vt[0:1][0:2] = '{'{1,2,3},'{4,5,6}};
real rinit = 2.5; integer iinit = 7;
(* desc="an output var", units="V" *) real ov;
analog begin
 @(initial_step) begin
  neg[-2] = 22; neg[2] = -22;
  b = "Hi"; a = {i{"Hi"}}; k = i;
  $strobe("str1: myName=[%s] s1=[%s] names=[%s,%s,%s] paths[2][1]=[%s]", myName, s1, names[1], names[2], names[3], paths[2][1]);
  $strobe("str2: {i{Hi}}=[%s] {5{Hi}}=[%s] {a,b}=[%s] {Hi,b}=[%s] {H,e}=[%s] e=[%s]", a, {5{"Hi"}}, {a,b}, {"Hi",b}, {"H",e}, e);
  $strobe("str3: eq=%d ne=%d lt=%d le=%d gt=%d ge=%d (1 0 0 1 0 1)", myName=="John Smith", myName!="John Smith", "abc"<"abc", "abc"<="abc", "abc">"abd", b>="Hi");
  $strobe("arr: neg[-2]=%d neg[2]=%d neg[0]=%d vt[1][2]=%g rinit=%g iinit=%d", neg[-2], neg[2], neg[0], vt[1][2], rinit, iinit);
  ov = 1.25;
 end
 I(p,n) <+ V(p,n);
end
endmodule
