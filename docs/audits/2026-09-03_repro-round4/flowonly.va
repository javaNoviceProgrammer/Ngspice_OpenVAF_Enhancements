`include "disciplines.vams"
module flowonly(p,n); inout p,n; electrical p,n; current sfi;
analog begin I(sfi) <+ 1e-3; I(p,n) <+ 2*I(sfi); $strobe("I(sfi)=%g (1e-3) I(p,n)=%g (2e-3)", I(sfi), I(p,n)); end endmodule
