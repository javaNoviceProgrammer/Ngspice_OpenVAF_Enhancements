`include "disciplines.vams"
`line 500 "fake.va" 0
module linedir(p,n); inout p,n; electrical p,n; analog @(initial_step) $strobe("line=%d file=%s (LRM 10.7/IEEE 1364 19.7 after `line 500: 500 fake.va -- the number names the NEXT line)", `__LINE__, `__FILE__); endmodule
