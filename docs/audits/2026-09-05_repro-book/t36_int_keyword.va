`include "disciplines.vams"
`include "constants.vams"
module m(inout electrical a, b);
int A[10:1];
analog I(a,b) <+ V(a,b);
endmodule
