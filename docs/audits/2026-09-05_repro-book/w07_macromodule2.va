`include "disciplines.vams"
`include "constants.vams"
macromodule mm(inout electrical a, b);
analog I(a,b) <+ V(a,b);
endmodule
