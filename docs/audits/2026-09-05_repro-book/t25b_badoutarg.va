`include "disciplines.vams"
`include "constants.vams"
module m(inout electrical a, b);
analog function real boxcalc;
  input h, w; output area, diag;
  real area, w, h, diag;
  begin area = h * w; diag = hypot(h, w); end
endfunction
real ar, dummy;
analog begin
  dummy = boxcalc(1.5, 2.5, ar/2, V(a));
  I(a,b) <+ V(a,b) + dummy;
end
endmodule
