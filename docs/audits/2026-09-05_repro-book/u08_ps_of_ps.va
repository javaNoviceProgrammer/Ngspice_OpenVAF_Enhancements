`include "disciplines.vams"
`include "constants.vams"
module vres(inout electrical p, n);
parameter string MAT = "poly" from '{"poly","metal"};
parameter real W = 1.0u from (0.0:inf);
parameter real L = 2.0u from (0.0:inf);
parameter real RSH = 100.0;
(* desc="effective resistance" *) real reff;
analog begin reff = RSH*L/W; I(p,n) <+ V(p,n)/reff; end
endmodule
paramset base vres;
parameter string KIND = "poly";
.MAT = KIND; .RSH = 80.0;
endparamset
paramset child base;
parameter real LEN = 3u;
.KIND = "metal"; .L = LEN;
endparamset
