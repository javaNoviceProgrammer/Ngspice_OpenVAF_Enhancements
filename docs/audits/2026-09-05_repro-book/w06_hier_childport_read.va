`include "disciplines.vams"
`include "constants.vams"
module leaf(inout electrical p, n);
analog I(p,n) <+ V(p,n);
endmodule
module top(inout electrical a, b);
leaf u1(a, b);
analog V(a) <+ 0.0*V(u1.p);
endmodule
