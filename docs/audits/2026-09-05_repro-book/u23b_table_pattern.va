`include "disciplines.vams"
`include "constants.vams"
module m(inout electrical a, b);
analog I(a,b) <+ $table_model(V(a,b), '{1.0,2.0,3.0}, '{0.5,1.0,1.5});
endmodule
