`include "disciplines.vams"
`include "constants.vams"
module drv(inout electrical x, y);
branch (x, y) br;
analog I(br) <+ V(br);
endmodule
module top(inout electrical m, o);
drv d1(m, o);
analog V(m) <+ 1.0*V(d1.br);
endmodule
