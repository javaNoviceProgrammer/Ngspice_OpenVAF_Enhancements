`include "disciplines.vams"
`include "constants.vams"
module m(inout electrical a, b);
parameter integer shape = 1, NS = 3;
real g, x, total, T1;
integer i;
analog begin
  case (shape)
    1, 3: g = 1.0;
    2, 4, 6: g = 0.5;
    default: $strobe("shape %d is not handled", shape);
  endcase
  total = 0.0;
  for (x = 0.0; x != 4; x = x + 1.0) total = total + x*x;
  i = 0; T1 = 0.0;
  repeat (NS-1) begin
    T1 = T1 + 1.0/(2.0 + i);
    i = i + 1;
  end
  I(a,b) <+ V(a,b)*(g + total + T1);
end
endmodule
