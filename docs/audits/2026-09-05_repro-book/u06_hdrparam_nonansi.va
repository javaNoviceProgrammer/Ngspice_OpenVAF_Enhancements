`include "disciplines.vams"
`include "constants.vams"
module cell #(parameter real WP = 60u) (a, b);
inout a, b; electrical a, b;
analog I(a,b) <+ V(a,b)*WP;
endmodule
