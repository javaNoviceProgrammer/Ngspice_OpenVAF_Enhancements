`include "disciplines.vams"
`include "constants.vams"
module m(inout electrical a, b);
thermal [0:1] dt;
ground [0:1] dt;
analog I(a,b) <+ V(a,b) + Temp(dt[0]);
endmodule
