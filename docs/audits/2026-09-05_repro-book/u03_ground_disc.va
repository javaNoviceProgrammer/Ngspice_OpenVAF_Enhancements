`include "disciplines.vams"
`include "constants.vams"
module m(inout electrical a, b);
ground electrical gnd;
analog I(a,b) <+ V(a,b) + V(a, gnd);
endmodule
