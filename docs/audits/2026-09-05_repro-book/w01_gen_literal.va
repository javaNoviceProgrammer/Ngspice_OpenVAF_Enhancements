`include "disciplines.vams"
`include "constants.vams"
module m(inout electrical a, b);
if (1) begin : blk electrical x; analog V(x) <+ V(a); end
analog I(a,b) <+ V(a,b) + V(blk.x);
endmodule
