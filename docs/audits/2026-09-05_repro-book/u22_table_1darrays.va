`include "disciplines.vams"
`include "constants.vams"
module m(inout electrical a, b);
real y[0:3], x[0:3], f[0:3];
analog initial begin y[0]=0;x[0]=1;f[0]=0.5; y[1]=0;x[1]=2;f[1]=1; y[2]=1;x[2]=1;f[2]=1.5; y[3]=1;x[3]=2;f[3]=2; end
analog I(a,b) <+ $table_model(0, V(a,b), y, x, f);
endmodule
