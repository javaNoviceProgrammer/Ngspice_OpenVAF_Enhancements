`include "disciplines.vams"
`include "constants.vams"
module drv(inout electrical x, y);
branch (x, y) br;
analog I(br) <+ V(br);
endmodule
module top(inout electrical m, o);
drv d1(m, o);
analog I(d1.br) <+ 4m;
endmodule
