`include "disciplines.vams"
`include "constants.vams"
module m(inout electrical a, b);
localparam integer sw = 0;
if (sw) electrical x; else electrical y;
if (sw) begin : blk electrical x; analog V(x) <+ V(a); end
analog I(a,b) <+ V(a,b) + V(genblk1.y);
endmodule
