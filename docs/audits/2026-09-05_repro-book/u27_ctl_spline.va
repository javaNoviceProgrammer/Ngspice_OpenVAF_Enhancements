`include "disciplines.vams"
`include "constants.vams"
module m(inout electrical a, b);
analog I(a,b) <+ $table_model(0.0, V(a,b), "sample.tbl", "3LL,2LL");
endmodule
