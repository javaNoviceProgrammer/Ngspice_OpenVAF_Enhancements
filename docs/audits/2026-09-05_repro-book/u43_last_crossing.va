`include "disciplines.vams"
`include "constants.vams"
module m(inout electrical a, b);
real t;
analog begin t = last_crossing(V(a)-0.5, +1) + last_crossing(V(a)-0.5); I(a,b) <+ V(a,b) + t; end
endmodule
