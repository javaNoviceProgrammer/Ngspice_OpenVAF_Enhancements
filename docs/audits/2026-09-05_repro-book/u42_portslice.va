`include "disciplines.vams"
`include "constants.vams"
module sumv (inout electrical [7:0] in, output electrical out);
analog V(out) <+ 0.5*(V(in[0]) + V(in[7]));
endmodule
module bank (input electrical [7:0] a, input electrical [3:0] b, output electrical c);
sumv s2 (.in({a[3], a[2], a[1], a[0], b}), .out(c));
endmodule
