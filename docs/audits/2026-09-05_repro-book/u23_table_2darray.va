`include "disciplines.vams"
`include "constants.vams"
module m(inout electrical a, b);
real grid[0:2][0:3] = '{'{0.0,0.0,1.0,1.0},'{1.0,2.0,1.0,2.0},'{2.0,4.0,3.0,5.0}};
analog I(a,b) <+ $table_model(0, V(a,b), grid);
endmodule
