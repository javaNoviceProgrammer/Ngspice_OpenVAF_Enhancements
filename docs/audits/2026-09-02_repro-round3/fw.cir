* fclose(mcd) and channel reuse
.control
pre_osdi fw.osdi
.endc
.model mm fw
n1 1 0 mm
v1 1 0 dc 1
.control
op
quit
.endc
.end
