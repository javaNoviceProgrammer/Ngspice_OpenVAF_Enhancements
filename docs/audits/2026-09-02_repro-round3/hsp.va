`include "disciplines.vams"
module hsp(p,n);
  inout p,n; electrical p,n;
  analog begin
    $strobe("HSP angle=%g hflip=%g vflip=%g x=%g m=%g", $angle, $hflip, $vflip, $xposition, $mfactor);
    I(p,n) <+ V(p,n)*1e-3;
  end
endmodule
