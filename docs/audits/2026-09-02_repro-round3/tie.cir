* tie
.control
pre_osdi tie.osdi
.endc
.model mm tie
n1 1 0 mm
v1 1 0 dc 1
.control
op
quit
.endc
.end
