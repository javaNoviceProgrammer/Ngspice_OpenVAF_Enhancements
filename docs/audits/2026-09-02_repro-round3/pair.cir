* strobe vs severity, identical placement
.control
pre_osdi pair.osdi
.endc
.model mm pair
n1 1 0 mm
v1 1 0 dc 1
.control
dc v1 1 5 1
quit
.endc
.end
