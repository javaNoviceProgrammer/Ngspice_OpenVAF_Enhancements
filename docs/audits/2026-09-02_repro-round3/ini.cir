* fclose(mcd) and channel reuse
.control
pre_osdi ini.osdi
.endc
.model mm ini
n1 1 0 mm
v1 1 0 dc 1
.control
op
quit
.endc
.end
