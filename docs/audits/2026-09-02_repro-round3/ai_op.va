`include "disciplines.vams"
module ai_op(p,n);
  inout p,n; electrical p,n;
  real r;
  analog initial begin
      r = ddt(1.0);               // analog operator
  end
  analog I(p,n) <+ V(p,n)*1e-3 + r*0.0;
endmodule
