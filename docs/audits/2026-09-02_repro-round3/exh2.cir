* fclose(mcd) and channel reuse
.control
pre_osdi exh2.osdi
.endc
.model mm exh2
n1 1 0 mm
v1 1 0 dc 1
.control
op
quit
.endc
.end
