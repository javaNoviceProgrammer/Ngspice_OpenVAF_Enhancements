`include "disciplines.vams"
module exh(p,n);
  inout p,n; electrical p,n;
  integer i, fdv, last;
  string nm;
  analog begin
    @(initial_step) begin
      last = 0;
      for (i = 0; i < 40; i = i + 1) begin
        $sformat(nm, "ex/e%0d.txt", i);
        fdv = $fopen(nm);
        if (i < 3 || i > 28)
          $strobe("EXH i=%0d mcd=%0d", i, fdv);
        last = fdv;
      end
    end
    I(p,n) <+ V(p,n)*1e-3;
  end
endmodule
