* fclose(mcd) and channel reuse
.control
pre_osdi reuse.osdi
.endc
.model mm reuse
n1 1 0 mm
v1 1 0 dc 1
.control
op
quit
.endc
.end
