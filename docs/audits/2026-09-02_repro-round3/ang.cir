* angle
.control
pre_osdi ang.osdi
.endc
.model mm ang
n1 1 0 mm
v1 1 0 dc 1
.control
op
quit
.endc
.end
