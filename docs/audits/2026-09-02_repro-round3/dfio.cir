* file write over a Newton walk
.control
pre_osdi dfio.osdi
.endc
.model mm dfio
n1 1 0 mm
r1 in 1 1k
v1 in 0 dc 1
.control
op
quit
.endc
.end
