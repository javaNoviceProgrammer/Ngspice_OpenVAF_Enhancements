fileio
v1 1 0 dc 1
n1 1 0 fm
.model fm fio
.control
pre_osdi fio.osdi
op
quit
.endc
.end
