* bus_buffer DC example: a single input driving a 4-bit vectored ("bus")
* output port. Each tap V(out[i]) should track gain*i/4 * V(in).
.model buf4 bus_buffer (gain=1.0)
Nbuf1 in out0 out1 out2 out3 buf4
Vin in 0 DC 1.0
.dc Vin -2 2 0.5
.control
  pre_osdi OSDIFILE
  run
  wrdata RESULTFILE v(in) v(out0) v(out1) v(out2) v(out3)
.endc
.end
