* shift_demo AC response: purely integer/bit-manipulation chain has ~zero
* small-signal sensitivity almost everywhere (floor()/shift derivatives are
* zero a.e.) -- this is expected to show a near-zero (very low dB) flat
* response, confirming there is no meaningful linearized AC transfer
* function for this operator class.
.model sm shift_demo(shift_amount=2)
vin in 0 dc 0.3 ac 1
n1 in out sm
rload out 0 1k

.ac dec 10 1 100meg
.control
pre_osdi shift_demo.osdi
run
wrdata ac_result.txt v(in) v(out)
.endc
.end
