// boolint.va -- Enhancement-845: a relational or logical result is the INTEGER
// 1 or 0 wherever it meets an integer (IEEE 1364 5.1.7, 5.1.9; Verilog-AMS LRM
// 4.2). openvaf-r types it Bool, and three places resolved Bool with Integer by
// casting the integer to 0 or 1: the ternary, == and !=, and a case statement
// whose expression is a comparison. Each output below is one such expression;
// the comment is its value for n = 5 (and x = 1 V on node x). Untyped
// parameters with such a default are in boolparam.va.
`include "disciplines.vams"

module boolint(x, t1, t2, t3, t4, t5, e1, e2, e3, e4, g1, g2, c1, c2, c3, k1,
               v1, v2, v3);
inout x, t1, t2, t3, t4, t5, e1, e2, e3, e4, g1, g2, c1, c2, c3, k1, v1, v2, v3;
electrical x, t1, t2, t3, t4, t5, e1, e2, e3, e4, g1, g2, c1, c2, c3, k1, v1, v2, v3;

parameter integer n = 5;
parameter integer m = 0;

integer k;

analog begin
  // the ternary
  V(t1) <+ ((n > 0) ? n : (n < 0));          // 5
  V(t2) <+ ((n < 0) ? (n > 0) : n);          // 5 (the logical branch first)
  V(t3) <+ ((n > 0) ? 2.5 : (n < 0));        // 2.5 (control: real branch)
  V(t4) <+ ((n > 0) ? (n > 1) : (n > 9));    // 1 (control: both logical)
  V(t5) <+ ((n > 0) ? (n && 7) : 300);       // 1 (the logical result is 1)

  // == and !=
  V(e1) <+ (n == (n > 0));                   // 0: 5 == 1
  V(e2) <+ (n != (n > 0));                   // 1
  V(e3) <+ ((n > 0) == 1);                   // 1 (control)
  V(e4) <+ ((m || n) != (10 | (-7)));        // 1: 1 != -5

  // $param_given is a logical result too
  V(g1) <+ ($param_given(n) == 2);           // 0: 1 == 2
  V(g2) <+ ($param_given(n) == 1);           // 1 (control)

  // case
  case (n > 0)
    5: V(c1) <+ 1;                           // 1 != 5: no match
    default: V(c1) <+ 2;                     // 2
  endcase
  case (n > 0)
    1: V(c2) <+ 1;                           // 1 (control)
    default: V(c2) <+ 2;
  endcase
  case (1)
    (n < 0): V(c3) <+ 1;
    (n > 0): V(c3) <+ 2;                     // 2 (control: the priority idiom)
    default: V(c3) <+ 3;
  endcase

  // into an integer variable
  k = (n > 0) ? n : (n < 0);
  V(k1) <+ k;                                // 5

  // at run time, from a node voltage
  V(v1) <+ ((V(x) > 0) ? n : (V(x) < 0));    // 5
  V(v2) <+ (n == (V(x) > 0));                // 0
  V(v3) <+ ((V(x) > 0) ? ((V(x) > 0) ? n : 0) : (V(x) < 0)) * V(x);  // 5
end
endmodule
