* cross() AC sweep -- V(out) exposes the event COUNTER, a piecewise-constant
* large-signal state with zero small-signal sensitivity, so this is a
* "documented non-behavior" check: the AC response is exactly 0 at every
* frequency.
.model crossmodel cross_demo(thresh=0.0 dir=0.0)

Vin in 0 DC 0 AC 1
Ndut in out crossmodel

.ac dec 20 1 1meg

.control
pre_osdi cross_demo.osdi
run
wrdata ac_cross.txt v(out)
quit
.endc
.end
