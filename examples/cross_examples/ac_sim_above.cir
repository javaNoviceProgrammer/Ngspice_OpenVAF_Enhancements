* above() AC sweep -- V(out) exposes the event COUNTER, a piecewise-constant
* large-signal state with zero small-signal sensitivity, so this is a
* "documented non-behavior" check: the AC response is exactly 0 at every
* frequency.
.model abovemodel above_demo(thresh=1.0)

Vin in 0 DC 0 AC 1
Ndut in out abovemodel

.ac dec 20 1 1meg

.control
pre_osdi above_demo.osdi
run
wrdata ac_above.txt v(out)
quit
.endc
.end
