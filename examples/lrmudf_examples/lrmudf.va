// Enhancement-521: analog user-defined functions, audited against Accellera
// VAMS-2023 clause 4.7 and fixed. Every value below is checked at RUN time.
`include "disciplines.vams"

module lrmudf(a, b);
  inout a, b; electrical a, b;
  parameter real p = 2.0;    // shadowed by the function-local p below
  parameter real q = 10.0;   // read through into the function
  real arr[0:1], brr[0:1], xrr[0:1], yrr[0:1];
  real dummy;
  (* desc="local k: 1+3 = 4"                     *) real r_local;
  (* desc="shadow: 1 + local p(3) + q = 14"      *) real r_shadow;
  (* desc="chained locals + param_given: 22"     *) real r_chain;
  (* desc="output array zero-init: 1"            *) real r_zinit;
  (* desc="arr reset: 10*0+0 = 0"                *) real r_reset;
  (* desc="mixed out/inout: 14"                  *) real r_mixed;
  (* desc="LRM Ex3 arrayadd: 100*8+16 = 816"     *) real r_ex3;

  // LRM 4.7.1: a parameter declared inside a function body is a compile-time
  // local; it shadows a same-named module parameter, other module parameters
  // read through (this crashed codegen: "attempted to read undefined value").
  analog function real floc;
    input x; real x;
    parameter real k = 3.0;
    begin
      floc = x + k;
    end
  endfunction

  analog function real fshadow;
    input x; real x;
    parameter real p = 3.0;      // shadows module p = 2.0
    begin
      fshadow = x + p + q;       // q is the module parameter
    end
  endfunction

  analog function real fchain;
    input x; real x;
    parameter real k1 = 2.0 * q;     // local default from a module param
    parameter real k2 = k1 + 1.0;    // local default from a previous local
    integer g;
    begin
      g = $param_given(k1);          // a local can never be given -> 0
      fchain = x + k1 + k2 + g;      // 1 + 20 + 21 + 0 = 42 at q=10
    end
  endfunction

  // LRM 4.7.2.3: a pure OUTPUT array is zero-initialized at entry, and an
  // unassigned one resets the caller's array to zeros (it used to get inout
  // copy-in semantics: the body read the caller's values).
  analog function real fzout;
    input u;
    output o;
    real u, o[0:1];
    begin
      fzout = u + o[0] + o[1];       // o reads {0,0}, never {5,6}
    end
  endfunction

  analog function real fmixed;
    input u;
    output o;
    inout io;
    real u, o[0:1], io[0:1];
    begin
      o[0] = u * 2.0;                // o[1] stays at its LRM zero
      io[0] = io[0] + 1.0;           // inout keeps copy-in/copy-out
      fmixed = o[0] + io[1];
    end
  endfunction

  // LRM 4.7.1 Example 3, verbatim declarations: the range on the DIRECTION
  // line ("unexpected token '['" before; the compiler's own name-then-range
  // rewrite even generated this form and then refused to parse it).
  analog function real arrayadd;
    inout [0:1]a;
    input [0:1]b;
    real a[0:1], b[0:1];
    integer i;
    begin
      for (i = 0; i < 2; i = i + 1) begin
        a[i] = a[i] + b[i];
      end
    end
  endfunction

  analog begin
    r_local  = floc(1.0);
    r_shadow = fshadow(1.0);
    r_chain  = fchain(1.0);

    arr[0] = 5.0; arr[1] = 6.0;
    r_zinit = fzout(1.0, arr);
    r_reset = 10.0*arr[0] + arr[1];      // arr must be {0,0} now

    arr[0] = 5.0; arr[1] = 6.0;
    brr[0] = 7.0; brr[1] = 8.0;
    r_mixed = fmixed(3.0, arr, brr);     // 6 + 8; arr -> {6,0}, brr -> {8,8}
    r_mixed = r_mixed + (arr[0] == 6.0 && arr[1] == 0.0 ? 0.0 : 1000.0)
                      + (brr[0] == 8.0 && brr[1] == 8.0 ? 0.0 : 1000.0);

    xrr[0] = 5.0; xrr[1] = 10.0;
    yrr[0] = 3.0; yrr[1] = 6.0;
    dummy = arrayadd(xrr, yrr);
    r_ex3 = 100.0*xrr[0] + xrr[1];       // {8,16} -> 816

    I(a,b) <+ 1e-3*V(a,b);
  end
endmodule
