* Smith-chart demo (Enhancement-254): pyplot -smith
* A resistive-capacitive two-port; .sp publishes S_1_1..S_2_2 vs frequency.
* `pyplot -smith` draws the reflection coefficients on a Smith chart.
V1 in 0 dc 0 ac 1 portnum 1 z0 50
R1 in out 30
C1 out 0 2p
V2 out 0 dc 0 ac 0 portnum 2 z0 50
.sp lin 21 10meg 5g 1
.control
run
set pyplot_terminal=png
* S11 and S22 on one Smith chart -> smith_demo.png
pyplot smith_demo -smith S_1_1 S_2_2
* dump S11 so the verify can confirm the plotted curve is the true coefficient
wrdata s11.dat S_1_1
* a matched load (Gamma = 0) lands at the chart center -> smith_match.png
let gmatch = 0*S_1_1
pyplot smith_match -smith gmatch
.endc
.end
