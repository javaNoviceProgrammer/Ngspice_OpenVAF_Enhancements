`include "disciplines.vams"
module bs1(a, c);
  inout a, c; electrical a, c;
  analog begin
    $bound_step(1e-6);
    I(a,c) <+ V(a,c)/1e3;
  end
endmodule
