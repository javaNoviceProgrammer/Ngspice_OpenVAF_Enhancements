`include "disciplines.vams"

// 5th-order analog Bessel low-pass filter, fc = 1000 Hz, realized purely
// via laplace_nd -- no actual RLC network in the model. Coefficients are the
// exact scipy.signal.bessel(N=5, Wn=2*pi*1000, analog=True, norm='phase')
// output, generated by design_bessel.py (do not hand-edit; regenerate instead).
module bessel5(in, out);
    input in;
    output out;
    electrical in, out;

    analog begin
        V(out) <+ laplace_nd(V(in), '{9.79262991312900096e+18}, '{9.79262991312900096e+18, 6.13487665087554400e+15, 1.70816496602651050e+12, 2.67532354915964007e+08, 2.39433418235021163e+04, 1.00000000000000000e+00});
    end
endmodule
