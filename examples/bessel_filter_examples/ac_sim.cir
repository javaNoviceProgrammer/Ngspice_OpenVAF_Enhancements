* bessel5 AC sweep: 5th-order analog Bessel low-pass filter, fc = 1kHz
.model bes5 bessel5
Ndut in out bes5
Vin in 0 DC 0 AC 1
.ac dec 50 1 1meg
.control
  pre_osdi bessel5.osdi
  run
  wrdata ac.txt vdb(out) vp(out)
.endc
.end
