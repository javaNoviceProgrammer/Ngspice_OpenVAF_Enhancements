`include "disciplines.vams"
module bad_distexp(a, b, o);
  inout a, b, o; electrical a, b, o;
  analog begin
    begin : blk
      integer sd; sd = 1;
      V(o) <+ $dist_exponential(sd, -1);
    end
    I(a, b) <+ V(a, b) / 1e3;
  end
endmodule
