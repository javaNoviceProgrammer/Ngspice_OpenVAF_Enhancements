// finalstep_demo.va -- Enhancement-53: @(final_step) + analysis-phase lists
//
// LRM 5.10.2: `initial_step`/`final_step` are active during the solution of
// the first/last point of an analysis; an optional list of quoted analysis
// names restricts the event to matching analyses (same names as analysis()).
// Before E-53, final_step never fired (E-7's documented fail-safe) and the
// parsed phase list was silently dropped.
`include "disciplines.vams"

// event logger: every step-event flavor, tagged for the verify script
module fslog(p, n);
  inout p, n;
  electrical p, n;
  analog begin
    @(initial_step)         $strobe("FS_LOG initial       t=%g", $abstime);
    @(initial_step("tran")) $strobe("FS_LOG initial_tran  t=%g", $abstime);
    @(initial_step("ac"))   $strobe("FS_LOG initial_ac    t=%g", $abstime);
    @(initial_step("dc"))   $strobe("FS_LOG initial_dc    t=%g", $abstime);
    @(final_step)           $strobe("FS_LOG final         t=%g V=%g", $abstime, V(p, n));
    @(final_step("tran"))   $strobe("FS_LOG final_tran    t=%g", $abstime);
    @(final_step("ac"))     $strobe("FS_LOG final_ac      t=%g", $abstime);
    @(final_step("dc"))     $strobe("FS_LOG final_dc      t=%g", $abstime);
    // multi-phase list: fires in either analysis
    @(initial_step("ac", "tran")) $strobe("FS_LOG initial_actran t=%g", $abstime);
    I(p, n) <+ V(p, n) / 1e3;
  end
endmodule

// the LRM's classic final_step use case: accumulate during the analysis,
// report a summary exactly once at the end
module fspeak(p, n);
  inout p, n;
  electrical p, n;
  real vpeak;
  analog begin
    @(initial_step) vpeak = V(p, n);
    if (V(p, n) > vpeak)
      vpeak = V(p, n);
    @(final_step) $strobe("FS_PEAK vpeak=%g", vpeak);
    I(p, n) <+ V(p, n) / 1e3;
  end
endmodule

// Enhancement-677 (hunt F6 of 2026-09-19): the final_step evaluation of an
// AC or NOISE analysis ran on the small-signal solution at the last frequency
// -- V(p,n) read the response (1 V for a unit AC source at a 0.2 V bias) and
// last_crossing() read 0, a valid time, where LRM 4.5.10 requires a negative
// value before any crossing. It runs on the bias point the analysis
// linearised around.
module fsop(p, n);
  inout p, n;
  electrical p, n;
  real tl;
  analog begin
    tl = last_crossing(V(p, n) - 0.5, 0);
    @(final_step) $strobe("FS_OP V=%g tl=%g", V(p, n), tl);
    I(p, n) <+ V(p, n) / 1e3;
  end
endmodule

// Enhancement-683 (hunt F2 of 2026-09-21): @(final_step) never fired under
// pz, tf, sens, disto and sp (those analyses did not call the OSDI final
// step), and under ac and noise it fired but the instance was restored
// afterwards (E-412's snapshot, written for an evaluation at a small-signal
// solution), so a counter assigned in the block read 0 afterwards. It fires
// once at the end of every analysis, at the bias point, and its assignments
// stay -- as after an op or a transient.
module fscnt(p, n);
  inout p, n;
  electrical p, n;
  (* desc="final_step count" *) integer cf;
  (* desc="V at final_step" *) real vf;
  analog begin
    @(final_step) begin
      cf = cf + 1;
      vf = V(p, n);
      $strobe("FS_CNT cf=%d V=%g", cf, V(p, n));
    end
    I(p, n) <+ V(p, n) / 1e3;
  end
endmodule

// Enhancement-789 (openvaf-r hunt F6 of 2026-10-04): sensitivity analysis
// re-runs setup and the temperature pass once per perturbed parameter and once
// per AC frequency, and each pass re-fired @(initial_step) -- 7 to 11 times
// under `sens v(a)`, 4 under a three-frequency AC sensitivity -- against the
// one @(final_step) of E-683. A model opening a file in one and closing it in
// the other saw the pair unbalanced. The two parameters give the dc
// sensitivity something to perturb.
module fsinit(p, n);
  inout p, n;
  electrical p, n;
  parameter real g = 1m;
  parameter real h = 2;
  integer opens;
  analog begin
    @(initial_step) begin
      opens = opens + 1;
      $strobe("FS_INIT opens=%d", opens);
    end
    @(final_step) $strobe("FS_BAL opens=%d", opens);
    I(p, n) <+ V(p, n) * g * h;
  end
endmodule
