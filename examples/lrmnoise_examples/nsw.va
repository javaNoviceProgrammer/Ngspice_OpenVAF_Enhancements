// Round-4 audit: noise and ac_stim on a SWITCH BRANCH (LRM 5.6.5 switch
// branches, 5.6.1.3 value retention, 4.6.4 noise, 6.3.6 $mfactor scaling).
//
// Two defects lived here, both invisible on a plain branch:
//
//   * a noise-only contribution in the arm lowered SECOND was dropped, so
//     `else V(p,n) <+ white_noise(...)` left the branch a pure flow source
//     and the arm's noise vanished (4.07e-9 -- the load resistor alone --
//     where the device's own 1e-6 was due). Writing the same two arms in
//     the other order worked, which is what made it an order dependence
//     rather than a missing feature.
//
//   * every source on a switch branch is injected into the branch-CURRENT
//     equation, whose coupling to the nodes already carries $mfactor, so a
//     current-arm source that also took sqrt(mfactor) scaled as m^1.5: a
//     netlist `m=9` read 2.70e-3 where 6.3.6's "noise power multiplied by
//     $mfactor" gives 3.00e-4. `ac_stim` on the same arm read 8.1 V for
//     0.9 V.
//
// Every module below is the SAME circuit -- a 1 mS conductance with a
// 1e-12 A^2/Hz white source, or the 0 V/1e-12 V^2/Hz potential form -- so
// the switch branch must match the plain branch value for value.
`include "disciplines.vams"

// flow arm written FIRST: the noise-only potential arm is lowered second,
// which is the order that used to drop it
module nswf(p, n);
    inout p, n;
    electrical p, n;
    parameter integer sw = 0;
    analog begin
        if (sw) I(p, n) <+ white_noise(1e-12, "wn") + V(p, n) * 1e-3;
        else    V(p, n) <+ white_noise(1e-12, "wn");
    end
endmodule

// the same two arms written the other way round
module nswp(p, n);
    inout p, n;
    electrical p, n;
    parameter integer sw = 1;
    analog begin
        if (sw) V(p, n) <+ white_noise(1e-12, "wn");
        else    I(p, n) <+ white_noise(1e-12, "wn") + V(p, n) * 1e-3;
    end
endmodule

// the plain flow branch the switch branch's flow arm must equal
module nplain(p, n);
    inout p, n;
    electrical p, n;
    analog I(p, n) <+ white_noise(1e-12, "wn") + V(p, n) * 1e-3;
endmodule

// ac_stim on a switch branch: same injection point, same $mfactor rule
module nswac(p, n);
    inout p, n;
    electrical p, n;
    parameter integer sw = 0;
    analog begin
        if (sw) V(p, n) <+ ac_stim("ac", 1.0, 0.0);
        else    I(p, n) <+ ac_stim("ac", 1e-3, 0.0) + V(p, n) * 1e-3;
    end
endmodule

// ...and the plain branch it must equal
module nplainac(p, n);
    inout p, n;
    electrical p, n;
    analog I(p, n) <+ ac_stim("ac", 1e-3, 0.0) + V(p, n) * 1e-3;
endmodule
