`include "disciplines.vams"
module dut(p, n);
  inout p, n;
  electrical p, n;
  parameter real k1 = 1e-3 from (0:inf);
  parameter real k2 = 2e-3 from (0:inf);
  analog begin
    begin : b2 integer i; real s; s = 0.0; for (i=0;i<4;i=i+1) s = s + k1*V(p,n); I(p,n) <+ s; end
  end
endmodule
