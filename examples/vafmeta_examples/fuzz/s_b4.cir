meta
V1 in 0 dc 0.5 ac 1
Rs in a 1k
N1 a 0 dut
.model dut dut()
.control
option noacct
set numdgt=17
pre_osdi /Users/meisam/git/Ngspice_OpenVAF_Enhancements/examples/vafmeta_examples/fuzz/j_b4/dut.osdi
dc V1 -1 1 0.25
print v(a)
ac lin 3 1e3 1e6
print vdb(a)
.endc
.end
