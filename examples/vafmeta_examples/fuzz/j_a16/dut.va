`include "disciplines.vams"
module dut(d, g, sx);
  inout d, g, sx;
  electrical d, g, sx;
  parameter real k1 = 1e-3 from (0:inf);
  parameter real k2 = 1e-3 from (0:inf);
  analog begin
    I(d,sx) <+ k1*V(d,sx); I(d,sx) <+ k2*V(d,sx); I(g,sx) <+ k2*V(g,sx);
  end
endmodule
