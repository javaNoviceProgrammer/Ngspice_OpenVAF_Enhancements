`include "disciplines.vams"
module dut(p, n);
  inout p, n;
  electrical p, n;
  parameter real k1 = 1e-3 from (0:inf);
  parameter real k2 = 2e-3 from (0:inf);
  analog begin
    I(p,n) <+ (V(p,n) > 0) ? ((V(p,n) > 1) ? k1 : k2) : k2;
  end
endmodule
