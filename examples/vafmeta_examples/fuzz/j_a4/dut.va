`include "disciplines.vams"
module dut(p, n);
  inout p, n;
  electrical p, n;
  parameter real k1 = 1e-3 from (0:inf);
  parameter real k2 = 2e-3 from (0:inf);
  analog begin
    begin : b1 real t; t = k1*V(p,n); I(p,n) <+ t + k2*t; end
  end
endmodule
