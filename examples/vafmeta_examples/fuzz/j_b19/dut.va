`include "disciplines.vams"
module dut(d, g, sx);
  inout d, g, sx;
  electrical d, g, sx;
  parameter real k1 = 1e-3 from (0:inf);
  parameter real k2 = 1e-3 from (0:inf);
  analog begin
    I(d,sx) <+ 1e-14*(exp(V(d,sx)/0.025)-1.0); I(g,sx) <+ k2*V(g,sx);
  end
endmodule
