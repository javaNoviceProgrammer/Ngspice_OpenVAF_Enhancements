meta3
V1 in 0 dc 0.5 ac 1
Vg gg 0 dc 0.3
Rs in a 1k
Rg gg g 1k
N1 a g 0 dut
.model dut dut()
.control
option noacct
set numdgt=17
pre_osdi /Users/meisam/git/Ngspice_OpenVAF_Enhancements/examples/vafmeta_examples/fuzz/j_b19/dut.osdi
dc V1 -0.5 0.5 0.25
print v(a)
ac lin 3 1e3 1e6
print vdb(a)
.endc
.end
