`include "disciplines.vams"
module dut(p, n);
  inout p, n;
  electrical p, n;
  parameter real k1 = 1e-3 from (0:inf);
  parameter real k2 = 2e-3 from (0:inf);
  analog begin
    begin : b3 integer i; real s; s = 0.0; i = 0; while (i < 3) begin s = s + k1*V(p,n); i = i + 1; end I(p,n) <+ s; end
  end
endmodule
