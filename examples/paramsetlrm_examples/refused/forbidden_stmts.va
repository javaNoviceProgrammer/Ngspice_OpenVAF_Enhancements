`include "disciplines.vams"
module vres(inout electrical p, n);
parameter real R = 1k;
analog I(p,n) <+ V(p,n)/R;
endmodule
paramset rp vres;
real q;
.R = 2k;
I(p,n) <+ 1.0;
@(initial_step) q = 1;
begin : nb q = 2; end
q = V(p,n);
endparamset
