* module-instantiation resistor-divider AC sweep (include-boundary variant)
.model dividermodel_inc divider

Vin in 0 DC 1.0 AC 1
Ndut in out 0 dividermodel_inc

.ac dec 20 1 1meg

.control
pre_osdi resistor_divider_include.osdi
run
wrdata ac_include.txt vdb(out) vp(out)
quit
.endc
.end
