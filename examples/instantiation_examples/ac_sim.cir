* module-instantiation resistor-divider AC sweep
.model dividermodel divider

Vin in 0 DC 1.0 AC 1
Ndut in out 0 dividermodel

.ac dec 20 1 1meg

.control
pre_osdi resistor_divider.osdi
run
wrdata ac.txt vdb(out) vp(out)
quit
.endc
.end
