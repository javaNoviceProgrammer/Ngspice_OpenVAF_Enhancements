`include "disciplines.vams"
module leafd(p, n); inout p, n; electrical p, n;
analog V(p,n) <+ 1.0;
endmodule
module hb10(p, n); inout p, n; electrical p, n;
leafd l1(p, n);
analog V(p,n) <+ 2.0;
endmodule
