`include "disciplines.vams"
module leafr(p, n); inout p, n; electrical p, n;
analog I(p,n) <+ V(p,n)/500;
endmodule
module hb(p, n); inout p, n; electrical p, n;
(* desc="own" *) real iop;
leafr l1(p, n);
analog begin I(p,n) <+ V(p,n)/1k; iop = I(p,n); end
endmodule
