`include "disciplines.vams"
module lit_pair(p, n);
  inout p, n; electrical p, n;
  analog I(p,n) <+ 1e-3 * $table_model(V(p,n), '{0.0,1.0,2.0,3.0}, '{0.0,1.0,4.0,9.0}, "1L");
endmodule
