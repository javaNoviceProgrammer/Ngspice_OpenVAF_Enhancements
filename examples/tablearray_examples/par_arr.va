`include "disciplines.vams"
module par_arr(p, n);
  inout p, n; electrical p, n;
  parameter real xs[0:3] = '{0.0, 1.0, 2.0, 3.0};
  parameter real ys[0:3] = '{0.0, 1.0, 4.0, 9.0};
  analog I(p,n) <+ 1e-3 * $table_model(V(p,n), xs, ys, "1L");
endmodule
