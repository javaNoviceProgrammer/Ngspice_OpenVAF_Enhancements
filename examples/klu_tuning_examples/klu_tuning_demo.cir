* klu_tuning_demo.cir -- KLU matrix ordering / scaling controls (Enhancement-152)
*
* A resistor grid solved with the KLU direct solver. The fill-reducing
* ordering (amd/colamd), row scaling (none/sum/max) and block-triangular-form
* permutation (on/off) are now selectable via .option; all give the same
* physical solution, differing only in factorization order / roundoff.
*
* Run:  ngspice -b klu_tuning_demo.cir

iin n_0_0 0 dc 1
vg n_7_7 0 dc 0
r1 n_0_0 n_1_0 100
r2 n_0_0 n_0_1 100
r3 n_0_1 n_1_1 100
r4 n_0_1 n_0_2 100
r5 n_0_2 n_1_2 100
r6 n_0_2 n_0_3 100
r7 n_0_3 n_1_3 100
r8 n_0_3 n_0_4 100
r9 n_0_4 n_1_4 100
r10 n_0_4 n_0_5 100
r11 n_0_5 n_1_5 100
r12 n_0_5 n_0_6 100
r13 n_0_6 n_1_6 100
r14 n_0_6 n_0_7 100
r15 n_0_7 n_1_7 100
r16 n_1_0 n_2_0 100
r17 n_1_0 n_1_1 100
r18 n_1_1 n_2_1 100
r19 n_1_1 n_1_2 100
r20 n_1_2 n_2_2 100
r21 n_1_2 n_1_3 100
r22 n_1_3 n_2_3 100
r23 n_1_3 n_1_4 100
r24 n_1_4 n_2_4 100
r25 n_1_4 n_1_5 100
r26 n_1_5 n_2_5 100
r27 n_1_5 n_1_6 100
r28 n_1_6 n_2_6 100
r29 n_1_6 n_1_7 100
r30 n_1_7 n_2_7 100
r31 n_2_0 n_3_0 100
r32 n_2_0 n_2_1 100
r33 n_2_1 n_3_1 100
r34 n_2_1 n_2_2 100
r35 n_2_2 n_3_2 100
r36 n_2_2 n_2_3 100
r37 n_2_3 n_3_3 100
r38 n_2_3 n_2_4 100
r39 n_2_4 n_3_4 100
r40 n_2_4 n_2_5 100
r41 n_2_5 n_3_5 100
r42 n_2_5 n_2_6 100
r43 n_2_6 n_3_6 100
r44 n_2_6 n_2_7 100
r45 n_2_7 n_3_7 100
r46 n_3_0 n_4_0 100
r47 n_3_0 n_3_1 100
r48 n_3_1 n_4_1 100
r49 n_3_1 n_3_2 100
r50 n_3_2 n_4_2 100
r51 n_3_2 n_3_3 100
r52 n_3_3 n_4_3 100
r53 n_3_3 n_3_4 100
r54 n_3_4 n_4_4 100
r55 n_3_4 n_3_5 100
r56 n_3_5 n_4_5 100
r57 n_3_5 n_3_6 100
r58 n_3_6 n_4_6 100
r59 n_3_6 n_3_7 100
r60 n_3_7 n_4_7 100
r61 n_4_0 n_5_0 100
r62 n_4_0 n_4_1 100
r63 n_4_1 n_5_1 100
r64 n_4_1 n_4_2 100
r65 n_4_2 n_5_2 100
r66 n_4_2 n_4_3 100
r67 n_4_3 n_5_3 100
r68 n_4_3 n_4_4 100
r69 n_4_4 n_5_4 100
r70 n_4_4 n_4_5 100
r71 n_4_5 n_5_5 100
r72 n_4_5 n_4_6 100
r73 n_4_6 n_5_6 100
r74 n_4_6 n_4_7 100
r75 n_4_7 n_5_7 100
r76 n_5_0 n_6_0 100
r77 n_5_0 n_5_1 100
r78 n_5_1 n_6_1 100
r79 n_5_1 n_5_2 100
r80 n_5_2 n_6_2 100
r81 n_5_2 n_5_3 100
r82 n_5_3 n_6_3 100
r83 n_5_3 n_5_4 100
r84 n_5_4 n_6_4 100
r85 n_5_4 n_5_5 100
r86 n_5_5 n_6_5 100
r87 n_5_5 n_5_6 100
r88 n_5_6 n_6_6 100
r89 n_5_6 n_5_7 100
r90 n_5_7 n_6_7 100
r91 n_6_0 n_7_0 100
r92 n_6_0 n_6_1 100
r93 n_6_1 n_7_1 100
r94 n_6_1 n_6_2 100
r95 n_6_2 n_7_2 100
r96 n_6_2 n_6_3 100
r97 n_6_3 n_7_3 100
r98 n_6_3 n_6_4 100
r99 n_6_4 n_7_4 100
r100 n_6_4 n_6_5 100
r101 n_6_5 n_7_5 100
r102 n_6_5 n_6_6 100
r103 n_6_6 n_7_6 100
r104 n_6_6 n_6_7 100
r105 n_6_7 n_7_7 100
r106 n_7_0 n_7_1 100
r107 n_7_1 n_7_2 100
r108 n_7_2 n_7_3 100
r109 n_7_3 n_7_4 100
r110 n_7_4 n_7_5 100
r111 n_7_5 n_7_6 100
r112 n_7_6 n_7_7 100

.control
  set numdgt=12

  echo --- default KLU (amd ordering, max scaling, BTF on) ---
  option klu
  op
  print v(n_2_3)

  echo --- COLAMD ordering + sum scaling, BTF off ---
  option klu klu_ordering=colamd klu_scale=sum klu_btf=off
  reset
  op
  print v(n_2_3)
.endc
.end
