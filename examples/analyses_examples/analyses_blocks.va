// Enhancement-62: OSDI building blocks for the ngspice-analysis validation
// suite -- a resistor, a capacitor, a temperature-dependent resistor, and
// an instance-parameter resistor ((*type="instance"*) exposes `r` at the
// instance level: N1 a 0 mm r=2k, alter @n1[r], .dc @n1[r] ...).
`include "disciplines.vams"

module ores(a,c); inout a,c; electrical a,c;
  parameter real r = 1e3;
  analog I(a,c) <+ V(a,c)/r;
endmodule

module ocap(a,c); inout a,c; electrical a,c;
  parameter real cap = 1e-9;
  analog I(a,c) <+ ddt(cap*V(a,c));
endmodule

module otres(a,c); inout a,c; electrical a,c;
  parameter real r0 = 1e3;
  parameter real tc = 0.01;
  analog I(a,c) <+ V(a,c)/(r0*(1.0 + tc*($temperature - 300.0)));
endmodule

module ires(a,c); inout a,c; electrical a,c;
  (* type="instance" *) parameter real r = 1e3;
  analog I(a,c) <+ V(a,c)/r;
endmodule

// Enhancement-684 (hunt F3 of 2026-09-21): which analyses answer analysis("ac").
// The operating points of .sp, .pz, .disto and an AC .sens answered "dc" while
// a plain .ac's answered "ac" (E-53's owning-analysis rule), so a model that
// selects its small-signal formulation under analysis("ac"), or fires
// @(initial_step("ac")), took the DC path there. They belong to "ac" now; .tf
// and a DC .sens stay "dc" (computed at zero frequency); noise stays "noise".
module aname(a,c); inout a,c; electrical a,c;
  (* type="instance" *) parameter real r = 1e3;
  (* desc="analysis ac" *) integer is_ac;
  (* desc="analysis dc" *) integer is_dc;
  (* desc="analysis static" *) integer is_static;
  (* desc="analysis noise" *) integer is_noise;
  analog begin
    is_ac = analysis("ac"); is_dc = analysis("dc");
    is_static = analysis("static"); is_noise = analysis("noise");
    @(initial_step("ac")) $strobe("AN_EV initial_ac");
    @(initial_step("dc")) $strobe("AN_EV initial_dc");
    @(final_step("ac")) $strobe("AN_EV final_ac");
    @(final_step("dc")) $strobe("AN_EV final_dc");
    @(final_step("noise")) $strobe("AN_EV final_noise");
    @(initial_step) $strobe("AN_NAME %s", $simparam$str("analysis_name", "?"));
    I(a,c) <+ V(a,c) / r;
  end
endmodule

// Enhancement-689 (hunt F7 of 2026-09-21): LRM 4.6.1's initial-condition idiom
// -- the capacitor's initial voltage applied as a potential contribution in the
// analysis("ic") branch. Under `tran ... uic` that branch used to run once in
// the unsolved evaluation `uic` makes and `ic` was dead; the loader now seeds
// the start vector from it, as a `.ic` on the nodes would.
module uicic(p, n); inout p, n; electrical p, n;
  (* type="instance" *) parameter real c = 1n from (0:inf);
  (* type="instance" *) parameter real ic = 0.5;
  (* desc="ic evaluations" *) integer nic;
  analog begin
    if (analysis("ic")) begin
      nic = nic + 1;
      V(p, n) <+ ic;
    end else begin
      I(p, n) <+ ddt(c * V(p, n));
    end
  end
endmodule
// an unconditional potential contribution: the device's own equation (a
// source), not an initial condition -- never seeded
module vpot(p, n); inout p, n; electrical p, n;
  (* type="instance" *) parameter real vdc = 1.0;
  analog V(p, n) <+ vdc;
endmodule
