`include "disciplines.vams"
// a plain linear resistor, so the deck's answer is analytic
module rmod(a, b);
    inout a, b;
    electrical a, b;
    parameter real r0 = 1e3 from (0:inf);
    analog I(a,b) <+ V(a,b) / r0;
endmodule
