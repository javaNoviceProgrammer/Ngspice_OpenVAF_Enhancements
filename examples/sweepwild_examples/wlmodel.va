// wlmodel.va -- Enhancement-268/-269 demo model.
//
// A two-terminal element whose resistance is R = wavelength * scale * 1k, with:
//   * `wavelength` -- a MODEL parameter (settable on the .model card),
//   * `scale`      -- an INSTANCE parameter (settable per device instance).
// So `@*[wavelength]` (E-268, model wildcard) co-varies the model parameter across
// every .model card, and `@#*[scale]` / `@*[[scale]]` (E-269, instance wildcard)
// co-vary the instance parameter across every device instance. `scale` defaults
// to 1, so with no scale set R = wavelength * 1k.
`include "disciplines.vams"

module wlmodel(p, n);
    inout p, n;
    electrical p, n;
    parameter real wavelength = 1.0;                    // model parameter
    (* type = "instance" *) parameter real scale = 1.0; // instance parameter
    analog V(p, n) <+ I(p, n) * wavelength * scale * 1000.0;
endmodule
