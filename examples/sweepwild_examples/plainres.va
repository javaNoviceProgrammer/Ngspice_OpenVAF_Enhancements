`include "disciplines.vams"
module plainres(p, n); inout p, n; electrical p, n;
 parameter real r = 2000.0; analog V(p,n) <+ I(p,n)*r; endmodule
