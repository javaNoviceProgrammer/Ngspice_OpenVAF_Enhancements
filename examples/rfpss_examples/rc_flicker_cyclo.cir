* Enhancement-126: cyclostationary flicker-noise demo.
* R1 (with a flicker model, AF=2) carries the RC low-pass current I(t) driven by the
* 1 MHz pump, so its flicker noise ~ KF*|I(t)|^2 is genuinely cyclostationary. The
* circuit is linear (fast, well-conditioned PSS) and the transfer to the output b is
* flat (= R1) over the low-frequency noise sweep, so the cyclostationary output noise
* satisfies (exact separable folding, Enhancement-178)
*     onoise(f) * f = R1^2 * KF * <|I(t)|>^2 = R1^2 * KF * (8/pi^2) * <I^2>,
*     <I^2> = (1/2)|(1 - H)/R1|^2,  H = 1/(1 + j*2*pi*f0*R1*C1),
* a constant independent of f: at f << f0 only the DC of the envelope |I(t)| feeds
* the 1/f band ("flicker sees <m>^2, white sees <m^2>"); the AC envelope power sits
* at sidebands of +-f0, +-2f0 where 1/f is negligible. (= 3.9526e-10 here; the old
* frequency-flat law <I^2> gave 4.8765e-10, 23% high.)
V1 a 0 SIN(0 1 1meg)
R1 a b rmod 1k
C1 b 0 1n
.model rmod R(kf=1e-9 af=2 ef=1)
.pnoise 1meg 1u b 1024 10 50 5u b v1 dec 3 100 1k cyclo
.control
run
print onoise_spectrum
.endc
.end
