`include "disciplines.vams"

// Enhancement-705: a two-input isoline file of 30 000 isolines (generated by
// verify_table.py: isoline y = i holds (x = 0, z = i) and (x = 1, z = i + 1)),
// interpolated linearly on both axes. The outer axis went through the same
// per-isoline chain of branches as a 1-D table's knots.
module table_iso(p, n);
    inout p, n; electrical p, n;
    parameter real y = 0.0;
    analog I(p, n) <+ 1e-6 * $table_model(y, V(p, n), "_big_iso.tbl", "1L,1L");
endmodule
