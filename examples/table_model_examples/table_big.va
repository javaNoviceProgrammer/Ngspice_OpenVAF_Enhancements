`include "disciplines.vams"

// Enhancement-705 (robustness campaign F1 of 2026-09-23): a 100 000-row data
// file. The file is generated by verify_table.py (y = (i*i mod 97) * 1e-6 at
// x = i * 1e-4, so every interpolated value has an exact reference). It used
// to overflow the compiler's stack: the interval search was a chain of one
// branch per knot, and the first recursive walk over 300 000 blocks died.
module table_big(p, n);
    inout p, n; electrical p, n;
    analog I(p, n) <+ $table_model(V(p, n), "_big_iv.tbl", "1L");
endmodule
