* Interactive syntax-highlighting demo (E-169 lexical + E-170 semantic).
*
* At an interactive ngspice prompt (any readline-enabled build -- as the shipped
* binaries are), the command line is colored live AS YOU TYPE. This deck previews
* that coloring non-interactively with the `synhl' command, which prints the
* colorized form of a line.  (Toggle the live feature off at the prompt with:
* set no_syntax_highlight  ; NO_COLOR is also honored.)
*
* A small voltage divider so that node signals a and b exist after `run'.
v1 a 0 dc 1
r1 a b 1k
r2 b 0 1k
.op

.control
echo
echo 'Lexical -- green = valid command, red = unknown, yellow = number,'
echo 'magenta = "string", cyan = -option :'
echo
synhl tran 1n 100n uic
synhl ac dec 10 1 1meg
synhl echo "hello world" -foo 3.14
synhl boguscommand 1 2 3
echo
echo 'Semantic (after run, so signals a and b exist) -- valid signals keep the'
echo 'default color, unknown signals and malformed expressions turn red:'
echo
run
synhl print v(a) v(b)
synhl print v(a) + v(zzz)
synhl print sqrt(v(a)) - v(bad)
synhl plot v(a)*/v(b)
synhl plot v(a) vs time
.endc

.end
