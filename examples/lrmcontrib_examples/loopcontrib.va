`include "disciplines.vams"
module loopcontrib(p, n);
  inout p, n; electrical p, n;
  integer k; integer nseg;
  analog begin
    nseg = (V(p,n) > 0) ? 3 : 2;
    for (k = 0; k < nseg; k = k + 1)
      I(p,n) <+ 1m * V(p,n);
  end
endmodule
