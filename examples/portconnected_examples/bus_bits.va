`include "disciplines.vams"
module leaf(inout electrical g, inout electrical [0:1] p);
(* desc="p0 connected" *) integer c0;
(* desc="p1 connected" *) integer c1;
(* desc="bits connected (genvar loop)" *) integer nb;
genvar i;
analog begin
  c0 = $port_connected(p[0]);
  c1 = $port_connected(p[1]);
  nb = 0;
  for (i = 0; i <= 1; i = i + 1)
    if ($port_connected(p[i])) nb = nb + 1;
  I(p[0], g) <+ V(p[0], g) * 1e-3;
  I(p[1], g) <+ V(p[1], g) * 1e-3;
end
endmodule
module top2(inout electrical g, x, y);
leaf u2 (g, {x, y});
leaf u3 (.g(g), .p({x, y}));
endmodule
