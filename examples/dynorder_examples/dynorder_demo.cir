LTE-based dynamic integration-order control demo (Enhancement-128)
* -------------------------------------------------------------------------
* A near-lossless parallel-RLC ringdown: a smooth 5.03 kHz sinusoid that
* higher-order Gear integrates with far larger steps than the stock
* controller, which never leaves order 2.
*
* Run it both ways and compare the step count printed by ngspice
* ("No. of Data Rows"):
*
*   ngspice -b dynorder_demo.cir                 (dynorder ON  -- this deck)
*   comment out the `dynorder` keyword below     (stock controller)
*
* With `set ngdebug` the dynamic controller also prints the highest Gear
* order it actually selected. On this circuit dynorder reaches order 4 and
* uses ~9x fewer timesteps at the same accuracy.
* -------------------------------------------------------------------------
L1 1 0 1m ic=0
C1 1 0 1u ic=1
R1 1 0 1meg

.option method=gear maxord=4 dynorder reltol=1e-7 abstol=1e-12

.tran 1u 2m 0 5u uic

.control
set ngdebug
run
let vend = v(1)[length(v(1))-1]
print vend
echo "(reference V(1) at 2ms ~ 0.9148 V)"
.endc
.end
