* generate-for resistor-ladder DC sweep
.model laddermodel ladder_generate

Vin in 0 DC 1.0
Ndut in out laddermodel
Rload out 0 1meg

.dc Vin -2 2 0.5

.control
pre_osdi resistor_ladder_generate.osdi
run
wrdata dc_generate.txt v(in) v(out)
quit
.endc
.end
