`include "disciplines.vams"
module leafe(a, b);
    inout a, b; electrical a, b;
    analog I(a,b) <+ 1e-3*V(a,b);
endmodule
module sysbad(p, n);
    inout p, n; electrical p, n;
    leafe #(.$vt(2)) u1 (p, n);
endmodule
