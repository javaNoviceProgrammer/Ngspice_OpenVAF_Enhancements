`include "disciplines.vams"
module leaf(a, b);
    inout a, b;
    electrical a, b;
    parameter real g = 1e-3;
    analog I(a,b) <+ g * V(a,b);
endmodule
module mid(a, b);
    inout a, b;
    electrical a, b;
    leaf #(.g(2e-3)) u2 (a, b);
endmodule
module dfp(p, n);
    inout p, n;
    electrical p, n;
    leaf #(.g(5e-3)) u1 (p, n);
    mid m1 (p, n);
    defparam u1.g = 10e-3;      // wins over #(.g(5e-3))
    defparam m1.u2.g = 20e-3;   // two levels down, wins over #(.g(2e-3))
endmodule
