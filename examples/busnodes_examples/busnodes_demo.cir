* busnodes_demo.cir -- Enhancement-221: array/bus node ranges in the netlist
*
* A node token of the form  base[lo:hi]  expands to the scalar node sequence
*   base[lo] base[lo±1] ... base[hi]
* (descending when lo>hi, Verilog convention), BEFORE device parsing. So the
* range supplies node tokens positionally:
*   R1 a[0:1] r=2k        ->  R1 a[0] a[1] r=2k          (a 2-terminal R)
*   X1 n[0:1] res2        ->  X1 n[0] n[1] res2          (a subckt call)
*   .subckt res2 p[1:0]   ->  .subckt res2 p[1] p[0]     (descending ports)
* An already-scalar name a[0] and the bus a[0:1] denote the SAME nodes, so the
* two forms interoperate. Values, model names and .control lines are untouched.
*
* This deck is checked purely from node voltages / branch currents, so it is
* solver-independent.

* --- a 2-terminal resistor written as a bus across a[0] and a[1] ---
V0 a[0] 0 dc 1
V1 a[1] 0 dc 3
R1 a[0:1] r=2k                 ; -> R1 a[0] a[1] : I = (1-3)/2k = -1mA

* --- the individual-element form addresses the same node a[0] ---
R2 a[0] gnda 4k
Vg gnda 0 dc 0                 ; I(R2) = 1/4k = 0.25mA

* --- a subcircuit whose ports are a descending bus, called with a bus ---
.subckt res2 p[1:0]
Rs p[0] p[1] 1k
.ends
X1 n[0:1] res2                 ; n[0]->p[1], n[1]->p[0]
V2 n[0] 0 dc 5
V3 n[1] 0 dc 0                 ; I(Rs) = (V(p[0])-V(p[1]))/1k = (0-5)/1k = -5mA

.op
.control
run
* R1 spans the bus a[0:1] -> a[0], a[1]
let i_r1 = @r1[i]
* R2 uses the scalar a[0] -- must be the SAME node as the bus element
let i_r2 = @r2[i]
* Rs inside the subckt, reached through the port bus
let i_rs = @r.x1.rs[i]
print i_r1 i_r2 i_rs
.endc
.end
