`include "disciplines.vams"
module vcvs(p, n);
    inout p, n; electrical p, n;
    analog I(p, n) <+ V(p, n) / 1k;
endmodule
