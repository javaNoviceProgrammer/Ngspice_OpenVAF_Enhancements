`include "disciplines.vams"
module dup(p, n);
    inout p, n; electrical p, n;
    analog I(p, n) <+ V(p, n) / 2k;
endmodule
