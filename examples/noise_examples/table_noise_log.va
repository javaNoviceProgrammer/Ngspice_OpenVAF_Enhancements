// table_noise_log.va — noise_table_log() from a data file (Enhancement-9)
//
// `noise_table_log("file")` takes the same `<frequency Hz> <power>` input as
// `noise_table()` (LRM 4.6.4.4) but interpolates LOG-LOG: for f between two
// tabulated points, P = 10^( log10(p1) + (log10(p2)-log10(p1)) *
// (log10(f)-log10(f1)) / (log10(f2)-log10(f1)) ). Outside the tabulated range
// the power clamps to the endpoint values. (Enhancement-109 corrected this --
// it used to expect a log10-frequency column and interpolate the raw power.)
`include "disciplines.vams"

module table_noise_log(p, n);
    inout p, n;
    electrical p, n;

    parameter real G = 1.0e-9 from (0:inf);

    analog begin
        I(p, n) <+ G * V(p, n);
        I(p, n) <+ noise_table_log("noise_table_log.txt", "measured_log");
    end
endmodule
