* Enhancement-321: swept param feeds a SUBCIRCUIT-INTERNAL device value
.param rval=1k
.subckt res a b
R1 a b {rval}
.ends
V1 in 0 1
X1 in out res
R2 out 0 1k
.control
sweep rval lin 9 100 900 -analysis op -output out -output i(v1)
wrdata _divider_sub_out.dat out i(v1)
.endc
.end
