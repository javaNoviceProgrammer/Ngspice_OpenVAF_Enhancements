// Enhancement-667 (hunt F9, 2026-09-18): four model-declared statistical
// parameters, three of them cornered. Under `.option osdimc corner=ss` the
// corner holds r, p and q, so the walk has ONE dimension (dr); wcd used to
// announce four and consume a coordinate for each held one. With r held at
// 1050 the free resistance is R = 1050 + dr ~ N(1050, 10): the spec
// i(v1) > -1/1090 lies 4 sigma out and FORM is exact, beta = 4. p and q do
// nothing to the current, so a metric of p alone is flat in the free axis.
`include "disciplines.vams"

module wcdcorner(a, b);
  inout a, b;
  electrical a, b;
  (* std=25.0, corner="ss=+2sigma, ff=-2sigma" *) parameter real r  = 1000.0 from (0:inf);
  (* type="instance", std=10.0 *)                  parameter real dr = 0.0;
  (* std=1.0, corner="ss=+1, ff=-1" *)             parameter real p  = 0.0;
  (* std=1.0, corner="ss=+1, ff=-1" *)             parameter real q  = 0.0;
  analog I(a, b) <+ V(a, b) / (r + dr) + 0.0 * (p + q) * V(a, b);
endmodule
