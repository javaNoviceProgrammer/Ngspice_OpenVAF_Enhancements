// Enhancement-70: behavioral (runtime) loop tour, self-checking -- each
// module's conductance is exactly hand-computable. Unlike `generate`
// (E-67), runtime loops MAY depend on module parameters (they execute at
// simulation time, so model-card overrides apply -- see lc_param).
`include "disciplines.vams"

// for: sum 1..4 -> 10 mS
module lc_for(a,c); inout a,c; electrical a,c;
  integer i; real acc;
  analog begin
    acc = 0.0;
    for (i = 1; i <= 4; i = i + 1)
      acc = acc + i;
    I(a,c) <+ V(a,c)*acc*1e-3;
  end
endmodule

// while / do-while / repeat: same 10 mS three ways
module lc_while(a,c); inout a,c; electrical a,c;
  integer i; real acc;
  analog begin
    acc = 0.0; i = 1;
    while (i <= 4) begin
      acc = acc + i;
      i = i + 1;
    end
    I(a,c) <+ V(a,c)*acc*1e-3;
  end
endmodule
module lc_dowhile(a,c); inout a,c; electrical a,c;
  integer i; real acc;
  analog begin
    acc = 0.0; i = 1;
    do begin
      acc = acc + i;
      i = i + 1;
    end while (i <= 4);
    I(a,c) <+ V(a,c)*acc*1e-3;
  end
endmodule
module lc_repeat(a,c); inout a,c; electrical a,c;
  real acc;
  analog begin
    acc = 0.0;
    repeat (10)
      acc = acc + 1.0;
    I(a,c) <+ V(a,c)*acc*1e-3;
  end
endmodule

// nested loops: 3 x 4 -> 12 mS
module lc_nested(a,c); inout a,c; electrical a,c;
  integer i, j; real acc;
  analog begin
    acc = 0.0;
    for (i = 0; i < 3; i = i + 1)
      for (j = 0; j < 4; j = j + 1)
        acc = acc + 1.0;
    I(a,c) <+ V(a,c)*acc*1e-3;
  end
endmodule

// PARAMETER-dependent bound: overridable at simulation time (.model n=25)
module lc_param(a,c); inout a,c; electrical a,c;
  parameter integer n = 10;
  integer i; real acc;
  analog begin
    acc = 0.0;
    for (i = 0; i < n; i = i + 1)
      acc = acc + 1.0;
    I(a,c) <+ V(a,c)*acc*1e-3;
  end
endmodule

// loop over an array (E-14): sum of weights -> 10 mS
module lc_array(a,c); inout a,c; electrical a,c;
  real w[0:3]; integer i; real acc;
  analog begin
    w[0] = 1.0; w[1] = 2.0; w[2] = 3.0; w[3] = 4.0;
    acc = 0.0;
    for (i = 0; i <= 3; i = i + 1)
      acc = acc + w[i];
    I(a,c) <+ V(a,c)*acc*1e-3;
  end
endmodule

// iterative algorithm: Newton sqrt(16) -> exactly 4 mS
module lc_newton(a,c); inout a,c; electrical a,c;
  integer i; real x;
  analog begin
    x = 8.0;
    for (i = 0; i < 20; i = i + 1)
      x = 0.5*(x + 16.0/x);
    I(a,c) <+ V(a,c)*x*1e-3;
  end
endmodule

// contribution inside a loop: 3 parallel 1k -> 3 mS
module lc_contrib(a,c); inout a,c; electrical a,c;
  integer i;
  analog begin
    for (i = 0; i < 3; i = i + 1)
      I(a,c) <+ V(a,c)*1e-3;
  end
endmodule

// loop in an analog function: iterative 5! -> 5 mS via /24k
module lc_fn(a,c); inout a,c; electrical a,c;
  analog function real factI;
    input n; integer n;
    integer k;
    begin
      factI = 1.0;
      for (k = 2; k <= n; k = k + 1)
        factI = factI * k;
    end
  endfunction
  analog I(a,c) <+ V(a,c)*factI(5)/24.0e3;
endmodule
