`include "disciplines.vams"

// Mixes an array-variable num/zero argument with an array-literal den
// argument in a single laplace_zd call, exercising Enhancement-4 Part 3.
// H(s) = (s+2e6) / (s^2 + 4e6 s + 3e12); H(0) = 2e6/3e12 = 6.667e-7
module laplace_mixed_var_literal(in, out);
    input in;
    output out;
    electrical in, out;

    real [0:0] zero_coeffs;

    analog begin
        zero_coeffs[0] = -2e6;
        // Enhancement-395: see laplace_zd_only.va -- the zero root normalises,
        // so the denominator coefficients carry the matching scale.
        V(out) <+ laplace_zd(V(in), zero_coeffs, '{1.5e6, 2.0, 5.0e-7});
    end
endmodule
