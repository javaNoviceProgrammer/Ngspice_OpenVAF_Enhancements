// Enhancement-86: hierarchical branch probes (LRM 5.4.1 / page 119 forms).
//
// `probes` reads, from OUTSIDE the instances:
//   o_vb  = V(top.a1.b)                -- named branch of instance a1 (1.34 V)
//   o_vub = V(top.d1.branch(va, vb))   -- unnamed branch of d1 (2.5 V)
//   o_ip  = I(top.d1.branch(<p>)) * 1k -- d1's OWN current into port p.
//
// d1 and d2 are identical 1k resistors in parallel across (a, gnd): the node
// current is 2*V(a)/1k, but the port-branch probe must read d1's share only
// -- the synthesized 0V ammeter discriminates instance current from node
// current.
`include "disciplines.vams"

module src(x);
   inout x; electrical x;
   electrical n, p;
   branch (n, p) b;
   analog begin
      V(b) <+ 1.34;
      I(p) <+ V(p)/1k;   // common-mode reference (node-to-ground) for the pair
      V(x) <+ V(n, p);
   end
endmodule

module rload(p, n);
   inout p, n; electrical p, n;
   electrical va, vb;
   analog begin
      V(va, vb) <+ 2.5;
      I(vb) <+ V(vb)/1k;   // common-mode reference for the pair
      I(p, n) <+ V(p, n)/1k;
   end
endmodule

module probes(o_vb, o_vub, o_ip);
   output o_vb, o_vub, o_ip;
   electrical o_vb, o_vub, o_ip;
   analog begin
      V(o_vb)  <+ V(top.a1.b);
      V(o_vub) <+ V(top.d1.branch(va, vb));
      V(o_ip)  <+ 1000.0 * I(top.d1.branch(<p>));
   end
endmodule

module top(a, o1, o_vb, o_vub, o_ip);
   inout a, o1, o_vb, o_vub, o_ip;
   electrical a, o1, o_vb, o_vub, o_ip;
   electrical gnd; ground gnd;
   src    a1 (o1);
   rload  d1 (a, gnd);
   rload  d2 (a, gnd);
   probes m1 (o_vb, o_vub, o_ip);
endmodule
