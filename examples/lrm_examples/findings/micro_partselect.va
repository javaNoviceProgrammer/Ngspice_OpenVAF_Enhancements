`include "disciplines.vams"
// F6 (open): part-selects in instance connections do not parse
module adc2(out, in);
   output [1:0] out; input in;
   electrical [1:0] out; electrical in;
   analog begin V(out[0]) <+ V(in); V(out[1]) <+ 2*V(in); end
endmodule
module adc4(out, in);
   output [3:0] out; input in;
   electrical [3:0] out; electrical in;
   adc2 hi (out[3:2], in);
   adc2 lo (out[1:0], in);
endmodule
