`include "disciplines.vams"
// F4 (fixed by E-85): `__FILE__/`__LINE__ predefined macros
module m(a, b);
   inout a, b; electrical a, b;
   analog begin
      $strobe("at %s:%d", `__FILE__, `__LINE__);
      V(a,b) <+ 1.0;
   end
endmodule
