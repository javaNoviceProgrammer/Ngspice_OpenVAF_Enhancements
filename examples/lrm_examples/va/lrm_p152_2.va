// Verilog-AMS LRM 2023 (Accellera), example from page 152
// extracted by lrm_examples/extract_lrm_examples.py (block_152_2)
`include "disciplines.vams"
`include "constants.vams"
    module tgate ();
       electrical io1,io2,control,control_bar;
       mosn m1 (io1, io2, control);
       mosp m2 (io1, io2, control_bar);
    endmodule
    module mosp (drain,gate,source);
       inout drain, gate, source;
       electrical drain, gate, source;
       parameter gate_length = 0.3e-6,
       gate_width  = 4.0e-6;
       spice_pmos #(.l(gate_length),.w(gate_width)) p (drain, gate, source);
    endmodule
    module mosn (drain,gate,source);
       inout drain, gate, source;
       electrical drain, gate, source;
       parameter gate_length = 0.3e-6,
       gate_width  = 4.0e-6;
       spice_nmos #(.l(gate_length),.w(gate_width)) n (drain, gate, source);
    endmodule

// [lrm_examples context] Annex E SPICE-compatibility MOS primitives
// (square-law level-1, 3-terminal), matching examples/annexe_examples (E-89).
module spice_nmos(d, g, s);
   inout d, g, s; electrical d, g, s;
   parameter real l = 1u from (0:inf);
   parameter real w = 1u from (0:inf);
   parameter real vto = 0.7;
   parameter real kp = 2e-5 from (0:inf);
   real vgs, vds, vov, ids;
   analog begin
      vgs = V(g, s); vds = V(d, s); vov = vgs - vto;
      if (vov <= 0.0)      ids = 0.0;
      else if (vds >= vov) ids = 0.5*kp*(w/l)*vov*vov;
      else                 ids = kp*(w/l)*(vov*vds - 0.5*vds*vds);
      I(d, s) <+ ids;
   end
endmodule
module spice_pmos(d, g, s);
   inout d, g, s; electrical d, g, s;
   parameter real l = 1u from (0:inf);
   parameter real w = 1u from (0:inf);
   parameter real vto = -0.7;
   parameter real kp = 1e-5 from (0:inf);
   real vsg, vsd, vov, isd;
   analog begin
      vsg = V(s, g); vsd = V(s, d); vov = vsg + vto;
      if (vov <= 0.0)      isd = 0.0;
      else if (vsd >= vov) isd = 0.5*kp*(w/l)*vov*vov;
      else                 isd = kp*(w/l)*(vov*vsd - 0.5*vsd*vsd);
      I(s, d) <+ isd;
   end
endmodule
