// Verilog-AMS LRM 2023 (Accellera), example from page 153
// extracted by lrm_examples/extract_lrm_examples.py (block_153_2)
`include "disciplines.vams"
`include "constants.vams"
    module m ();
       electrical clk;
       electrical out_a, in_a;
       electrical out_b, in_b;
       // create an instance and set parameters
       mosp #(2e-6,1e-6) weakp (out_a, in_a, clk);
       // create an instance leaving default values
       mosp plainp (out_b, in_b, clk);
    endmodule

// [lrm_examples context] the `mosp` wrapper from the page-152 example plus
// the Annex E spice_pmos it instantiates (E-89).
module mosp(drain, gate, source);
   inout drain, gate, source; electrical drain, gate, source;
   parameter real gate_length = 0.3e-6;
   parameter real gate_width  = 4.0e-6;
   spice_pmos #(.l(gate_length), .w(gate_width)) p(drain, gate, source);
endmodule
module spice_pmos(d, g, s);
   inout d, g, s; electrical d, g, s;
   parameter real l = 1u from (0:inf);
   parameter real w = 1u from (0:inf);
   parameter real vto = -0.7;
   parameter real kp = 1e-5 from (0:inf);
   real vsg, vsd, vov, isd;
   analog begin
      vsg = V(s, g); vsd = V(s, d); vov = vsg + vto;
      if (vov <= 0.0)      isd = 0.0;
      else if (vsd >= vov) isd = 0.5*kp*(w/l)*vov*vov;
      else                 isd = kp*(w/l)*(vov*vsd - 0.5*vsd*vsd);
      I(s, d) <+ isd;
   end
endmodule
