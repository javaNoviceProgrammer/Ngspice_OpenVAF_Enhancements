// Verilog-AMS LRM 2023 (Accellera), example from page 181
// extracted by lrm_examples/extract_lrm_examples.py (block_181_1)
`include "disciplines.vams"
`include "constants.vams"
    module a2d(dnet, anet);
       input dnet;
       output anet;
       wire dnet;
       ddiscrete dnet;
       electrical anet;
       real avar;
       analog begin
          if (dnet === 1'b1)
             avar = 5;
          else if (dnet === 1'bx)
             avar = avar; // hold value
          else if (dnet === 1'b0)
             avar = 0;
          else if (dnet === 1'bz)
             avar = 2.5; // high impedance - float value
          V(anet) <+ avar;
       end
    endmodule
