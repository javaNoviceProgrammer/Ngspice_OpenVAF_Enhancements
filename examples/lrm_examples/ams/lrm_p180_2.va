// Verilog-AMS LRM 2023 (Accellera), example from page 180
// extracted by lrm_examples/extract_lrm_examples.py (block_180_2)
`include "disciplines.vams"
`include "constants.vams"
    module onebit_dac (in, out);
       input in;
       inout out;
       wire in;
       electrical out;
       real x;
       analog begin
          if (in == 0)
             x = 0.0;
          else
             x = 3.0;
          V(out) <+ x;
       end
    endmodule
