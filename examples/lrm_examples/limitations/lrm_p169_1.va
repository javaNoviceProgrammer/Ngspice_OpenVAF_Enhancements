// Verilog-AMS LRM 2023 (Accellera), example from page 169
// extracted by lrm_examples/extract_lrm_examples.py (block_169_1)
`include "disciplines.vams"
`include "constants.vams"
    module rcline (n1, n2);
       inout n1, n2;
       electrical n1, n2, gnd;
       ground gnd;
       parameter integer N = 10 from (0:inf);
       electrical [0:N] n;
       parameter Cap = 1p, Res = 1k;
       localparam Csec = Cap/N, Rsec = Res/N;
       genvar i;
       // "generate" and "endgenerate" keywords are not required.
       for (i=0; i <N; i=i+1) begin
          resistor #(.r(Rsec)) R(n[i], n[i+1]);
          capacitor #(.c(Csec)) C(n[i+1], gnd);
       end
       analog begin
          V(n1, n[0]) <+ 0.0;
          V(n2, n[N]) <+ 0.0;
       end
    endmodule

// [lrm_examples context] Annex E SPICE-compatibility primitives the RC-line
// example instantiates but does not define, as plain Verilog-A modules.
// Enhancement-392 is what let this example elaborate at all: its loop bound `N`
// also sizes `electrical [0:N] n`, so Enhancement-92 had already frozen `N` to a
// localparam, and a localparam is a compile-time constant that may shape a
// generated structure. Only a parameter that shapes nothing stays rejected.
module resistor(p, n);
   inout p, n; electrical p, n;
   parameter real r = 1k;
   analog I(p, n) <+ V(p, n)/r;
endmodule
module capacitor(p, n);
   inout p, n; electrical p, n;
   parameter real c = 1p;
   analog I(p, n) <+ ddt(c*V(p, n));
endmodule
