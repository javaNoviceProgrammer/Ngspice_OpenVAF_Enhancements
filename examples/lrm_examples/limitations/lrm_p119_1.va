// Verilog-AMS LRM 2023 (Accellera), example from page 119
// extracted by lrm_examples/extract_lrm_examples.py (block_119_1)
`include "disciplines.vams"
`include "constants.vams"
    module signal_monitor;
       parameter refv = 2.3;
       electrical a;
       analog begin
          V(a) <+ refv;
          // Creates an unnamed branch in module signal_monitor between
          // nets top.drv.a and implicit ground.
          $strobe("voltage at top.drv.a = %g volts", V(top.drv.a));
          // Creates an unnamed branch in module signal_monitor between
          // nets top.drv.a and top.drv.b
          $strobe("voltage diff in top.drv = %g volts", V(top.drv.a, top.drv.b));
          // Creates an unnamed branch in module signal_monitor between
          // local net a and top.drv.a
          $strobe("voltage diff from ref in top.drv = %g volts", V(a,top.drv.a));
          // References the unnamed branch created in the first $strobe()
          // statement
          if(V(top.drv.a) > 10.0) $strobe("voltage limit exceeded at top.drv.a");
       end
    endmodule
    module top;
       A a1();
       B b1();
    endmodule
    module A;
       electrical n,p;
       branch (n,p) b;
       analog V(b) <+ 1.34;
    endmodule
    module B;
       analog $strobe("voltage == %g", V(top.a1.b));
    endmodule
    analog begin
       // strobes the voltage of the unnamed branch between
       // nets a and b in top.drv.
       $strobe("Voltage == %g", V(top.drv.branch(a,b)));
       // strobes the current flowing through the unnamed port
       // branch for the port p in top.drv
       $strobe("Current == %g", I(top.drv.branch(<p>)));
    end
    V(n1, n2) <+ expression;
    I(n1, n2) <+ expression;
    module resistor(p, n);
       inout p, n;
       electrical p, n;
       branch (p,n) path;  // named branch
       parameter real r = 0;
       analog
          V(path) <+ r*I(path);
    endmodule
    module capacitor(p, n);
       inout p, n;
       electrical p, n;
       parameter real c = 0;
       analog
          I(p,n) <+ c*ddt(V(p, n)); // unnamed branch p,n
    endmodule
    module measure2(p);
       output p;
       electrical p;
       parameter real V = 1.1;
       parameter real I = 1u;
       parameter real R = 10k;
       analog begin
          potential(p) <+ flow(p) * R; // create a resistor
          $strobe("voltage ratio at port 'p' is %g", potential(p) / V);
          $strobe("current ratio through port 'p' is %g", flow(<p>) / I);
       end
    endmodule
    module amp(out, in);
       input in;
       output out;
       electrical out, in;
       parameter real Gain = 1;
       analog
          V(out) <+ Gain*V(in);
    endmodule
    module amp(out, in);
       inout out, in;
       electrical out, in;
       parameter real Gain = 1, Rin = 1, Cin = 1, Rout = 1, Lout = 1;
       analog begin
          // gain of amplifier
          V(out) <+ Gain*V(in);
          // model input admittance
          I(in) <+ V(in)/Rin;
          I(in) <+ Cin*ddt(V(in));
          // model output impedance
          V(out) <+ Rout*I(out);
          V(out) <+ Lout*ddt(I(out));
       end
    endmodule
    if (closed)
       V(p,n) <+ 0;
    if (closed)
       V(p,n) <+ 0;
    else
       I(p,n) <+ 0;
    module value_ret(p, n);
       inout p, n;
       electrical p, n;
       analog begin
          V(p,n) <+ 1.0; // no previously-retained value, 1 is retained
          I(p,n) <+ 2.0; // potential discarded; flow of 2 retained
          V(p,n) <+ 3.0; // flow discarded; potential of 3 retained
          V(p,n) <+ 4.0; // 4 added to previously-retained 3
       end
    endmodule
    module cccs (p, n, ps, ns);
       inout p, n, ps, ns;
       electrical p, n, ps, ns;
       parameter real A = 1.0;
       analog begin
          I(p,n) <+ A * I(ps,ns);
       end
    endmodule
    module control_source (p, n, ps, ns);
       inout p, n, ps, ns;
       electrical p, n, ps, ns;
       parameter A=1;
       branch (ps,ns) in;
       branch (p,n) out;
       analog begin
       // add behavioral statement here
       end
    endmodule
      V(out) <+ A * V(in);
      I(out) <+ A * V(in);
      V(out) <+ A * I(in);
      I(out) <+ A * I(in);
            analog begin
            end
         endmodule
             analog begin
             end
          endmodule
    V(p, n) <+ R*I(p, n) + L*ddt(I(p, n)) + idt(I(p, n))/C;
    I(p, n) <+ V(p, n)/R + C*ddt(V(p, n)) + idt(V(p, n))/L;
    module relay (p, n, cp, cn);
       inout p, n, cp, cn;
       electrical p, n, cp, cn;
       branch (p,n) out;
       branch (cp,cn) ctrl;
       parameter real thresh = 0;
       analog begin
          @(cross(V(ctrl) - thresh, 0))
             ; // acts only to resolve threshold crossings
          if (V(ctrl) > thresh)
             V(out) <+ 0;
          else
             I(out) <+ 0; // optional due to value retention
       end
    endmodule
    I(diode) <+ is*(limexp((V(diode) - r*I(diode))/$vt) - 1);
    vin = 0,    (1)
    V(out) <+ V(out) + V(in);
    V(out): V(in) == 0;
    module opamp(out, pin, nin);
       inout out, pin, nin;
       electrical out, pin, nin;
       analog
          V(out):V(pin,nin) == 0;
    endmodule
    V(x): ddt(V(x)) == f(V(x), V(y), V(z));
    V(y): ddt(V(y)) == g(V(x), V(y), V(z));
    V(z): ddt(V(z)) == h(V(x), V(y), V(z));
    V(y): ddt(V(x)) == f(V(x), V(y), V(z));
    V(z): ddt(V(y)) == g(V(x), V(y), V(z));
    V(x): ddt(V(z)) == h(V(x), V(y), V(z));
    V(z): ddt(V(x)) == f(V(x), V(y), V(z));
    V(x): ddt(V(y)) == g(V(x), V(y), V(z));
    V(y): ddt(V(z)) == h(V(x), V(y), V(z));
    module source_driver();
       electrical m;
       parameter real vref = 0.0;
       analog begin
          V(m) <+ vref;
          // creates an unnamed voltage source branch of 1.8
          // volts between the net top.drv.x and implicit ground.
          V(top.drv.x) <+ 1.8;
          // creates an unnamed voltage source branch of 1.2
          // volts between nets top.drv.x and top.drv.y
          V(top.drv.x, top.drv.y) <+ 1.2;
          // creates an unnamed voltage source branch of 0.9
          // volts between the local net m and top.drv.y
          V(m, top.drv.y) <+ 0.9;
       end
    endmodule
    module source_driver();
       analog begin
          // contributes 1.8 volts to the named branch br_v in top.drv
          V(top.drv.br_v) <+ 1.8;
          // contributes 1.2 volts to the unnamed branch between
          // nets x and y in top.drv
          V(top.drv.branch(x,y)) <+ 1.2;
          // contributes 1mA to the named branch br_i in top.drv
          I(top.drv.br_i) <+ 1m;
       end
    endmodule
    wire [7:0] c1; // packed array of scalar wire types
    real u [7:0]; // unpacked array of real types
             int A[10:1]; // fixed-size array of 10 elements
             int B[0:9]; // fixed-size array of 10 elements
             int C[24:1]; // fixed-size array of 24 elements
             A = B; // ok. Compatible type and same size
             A = C; // type check error: different sizes
    if (expression)
    if (expression != 0)
    if (index > 0)
       if (i > j)
          result = i;
       else  // else applies to preceding if
          result = j;
    if (index > 0) begin
       if (i > j)
          result = i;
    end
    else result = j;
