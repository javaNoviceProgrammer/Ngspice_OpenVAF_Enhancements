`include "disciplines.vams"
module m_res(p, n);
  inout p, n;  electrical p, n;
  (*type="instance"*) parameter real r = 1000.0 from (0:inf);
  analog I(p,n) <+ V(p,n)/r;
endmodule
