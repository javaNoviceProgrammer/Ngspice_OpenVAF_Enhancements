`include "disciplines.vams"
module m_cap(p, n);
  inout p, n;  electrical p, n;
  (*type="instance"*) parameter real c = 1e-12 from (0:inf);
  analog I(p,n) <+ ddt(c*V(p,n));
endmodule
