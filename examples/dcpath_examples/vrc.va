`include "disciplines.vams"
module vrc(p, n);
  inout p, n; electrical p, n;
  analog I(p,n) <+ V(p,n)/1k + ddt(1p*V(p,n));
endmodule
