`include "disciplines.vams"
module vdiff(p, n);
  inout p, n; electrical p, n;
  analog V(p,n) <+ 1.0;
endmodule
