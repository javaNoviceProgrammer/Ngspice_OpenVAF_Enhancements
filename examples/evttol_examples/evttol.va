`include "disciplines.vams"

// Enhancement-911: a cross/above event lands in the LRM's box of its time and
// expression tolerances (LRM 5.10.3.1, Figure 5-6). The body prints the time
// and the expression's value where it ran.
module tolp(c, out);
  inout c, out;
  electrical c, out;
  parameter real vth = 0.5;
  parameter real ttol = 0.0;
  parameter real xtol = 0.0;
  parameter integer dir = 0;
  parameter integer useabove = 0;
  integer n;
  analog begin
    @(initial_step) n = 0;
    if (useabove == 0) begin
      @(cross(V(c) - vth, dir, ttol, xtol)) begin
        n = n + 1;
        $strobe("EV %d t=%.15e x=%.6e", n, $abstime, V(c) - vth);
      end
    end else begin
      @(above(V(c) - vth, ttol, xtol)) begin
        n = n + 1;
        $strobe("EV %d t=%.15e x=%.6e", n, $abstime, V(c) - vth);
      end
    end
    V(out) <+ n;
  end
endmodule
