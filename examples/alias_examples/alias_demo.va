// alias_demo.va -- Enhancement-12 demo of the mechanism-unavailable system
// functions: $simprobe and $analog_node_alias/$analog_port_alias.
//
// (The plusarg functions $test$plusargs/$value$plusargs were also in this group
// until Enhancement-215 gave them a real mechanism -- command-line plusargs served
// through the simparam channel -- so they moved to examples/plusargs_examples.)
//
// Neither of the two remaining functions has an underlying mechanism in the
// OSDI/ngspice target: OSDI models get no generic simulator-probe API and no
// runtime hierarchical node aliasing. Each therefore returns its LRM
// "mechanism-unavailable" result -- a well-defined constant -- so a model that
// uses them compiles and runs (rather than being rejected) with predictable
// behavior. The results are written to a file and checked by verify_alias.py.
//
//   $analog_node_alias(node, "nm") -> 0  (no alias created; analog-initial-only
//                                          per LRM 9.20, enforced since E-527)
//   $analog_port_alias(port, "nm") -> 0
//   $simprobe("inst", "q", d)      -> d   (the supplied default is returned)
//
// The NO-DEFAULT $simprobe form is deliberately absent here: LRM 9.16 makes an
// unresolvable probe with no default an ERROR, and since the E-527 kernel audit
// it warns at compile time and aborts at run time (verify_alias.py pins both
// refusals on separate fixtures).
`include "disciplines.vams"

module alias_demo(p, n);
    inout p, n;
    electrical p, n;

    // Enhancement-541 (LRM 9.20): the aliased net may not be a PORT -- "it
    // shall be an error for the analog_net_reference to be a port or to be
    // involved in port connections", and a port is already wired by the
    // instantiation, so there is no second position for an alias to move it
    // to. These two calls used to pass `p` and compiled clean; the local nets
    // are the legal spelling of the same probe, and the return value under
    // test (0, the unresolvable-reference fallback) is unchanged.
    electrical loc_n, loc_p;

    parameter real R = 1000.0 from (0:inf);

    integer f, na, pa;
    real    spd;

    analog initial begin
        na  = $analog_node_alias(loc_n, "p_alias");
        pa  = $analog_port_alias(loc_p, "p_alias");
    end

    analog begin
        I(p, n) <+ V(p, n) / R;

        spd = $simprobe("top.x1", "temp", 3.5);

        f = $fopen("alias_out.txt", "w");
        $fdisplay(f, "node_alias=%d", na);
        $fdisplay(f, "port_alias=%d", pa);
        $fdisplay(f, "simprobe_default=%g", spd);
        $fclose(f);
    end
endmodule
