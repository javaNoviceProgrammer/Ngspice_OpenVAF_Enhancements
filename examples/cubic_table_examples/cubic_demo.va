`include "disciplines.vams"

// Enhancement-22 demonstration: natural CUBIC SPLINE interpolation in
// $table_model (control code "3"), extending the piecewise-LINEAR (E-16) and
// multilinear (E-17) interpolation. A cubic spline is C1 -- its derivative is
// *continuous* -- so a table-based device's gm/gds are smooth, unlike the
// staircase derivative of linear interpolation. The spline is lowered to
// differentiable MIR (its per-point second-derivative "moments" are a
// compile-time-fixed linear operator on the grid values), so mir_autodiff
// supplies the exact, continuous Jacobian for free.

// I(p,n) = sin(V(p,n)) sampled on a coarse grid, CUBIC-interpolated.
module sin_cubic(p, n);
    inout p, n; electrical p, n;
    analog I(p, n) <+ $table_model(V(p, n), '{0,0.000000, 0.4,0.389418, 0.8,0.717356, 1.2,0.932039, 1.6,0.999574, 2,0.909297, 2.4,0.675463, 2.8,0.334988, 3.2,-0.058374}, "3");
endmodule

// Same data, piecewise-LINEAR (for the accuracy / smoothness comparison).
module sin_linear(p, n);
    inout p, n; electrical p, n;
    analog I(p, n) <+ $table_model(V(p, n), '{0,0.000000, 0.4,0.389418, 0.8,0.717356, 1.2,0.932039, 1.6,0.999574, 2,0.909297, 2.4,0.675463, 2.8,0.334988, 3.2,-0.058374}, "1");
endmodule

// Natural cubic spline reproduces straight-line data EXACTLY (all moments 0).
module line_cubic(p, n);
    inout p, n; electrical p, n;
    analog I(p, n) <+ $table_model(V(p, n), '{0,1, 0.4,1.8, 0.8,2.6, 1.2,3.4, 1.6,4.2, 2,5, 2.4,5.8, 2.8,6.6, 3.2,7.4}, "3");
endmodule

// 2-D tensor-product cubic spline of f(x,y) = sin(x)*cos(y) from a grid file.
module surf_cubic(p, n);
    inout p, n; electrical p, n;
    analog I(p, n) <+ $table_model(V(p), V(n), "surf.grid", "3,3");
endmodule

// Enhancement-704 (hunt F3 of 2026-09-21): LRM 9.21.4's END CONDITIONS. "If the
// user selects linear extrapolation this leads to a natural spline. If constant
// extrapolation is specified the end point derivative is set to zero thus
// avoiding a discontinuity in the first order derivative at that end point."
// y = x^2 sampled at 0..4 under each control; the values differ from the natural
// spline's everywhere, and under "C" the derivative runs to zero at the edge
// instead of jumping from 7.43 to 0 there.
module edge_cubic_c(p, n);
    inout p, n; electrical p, n;
    analog I(p, n) <+ $table_model(V(p, n), '{0,0, 1,1, 2,4, 3,9, 4,16}, "3C");
endmodule

module edge_cubic_l(p, n);
    inout p, n; electrical p, n;
    analog I(p, n) <+ $table_model(V(p, n), '{0,0, 1,1, 2,4, 3,9, 4,16}, "3L");
endmodule

module edge_cubic_lc(p, n);
    inout p, n; electrical p, n;
    analog I(p, n) <+ $table_model(V(p, n), '{0,0, 1,1, 2,4, 3,9, 4,16}, "3LC");
endmodule

module edge_cubic_cl(p, n);
    inout p, n; electrical p, n;
    analog I(p, n) <+ $table_model(V(p, n), '{0,0, 1,1, 2,4, 3,9, 4,16}, "3CL");
endmodule

// y = x under "3C": the clamped-end spline is NOT the line -- it bends to meet
// the flat extension with a zero derivative (3.98357 at 3.9, the line 3.9).
module edge_line_c(p, n);
    inout p, n; electrical p, n;
    analog I(p, n) <+ $table_model(V(p, n), '{0,0, 1,1, 2,2, 3,3, 4,4}, "3C");
endmodule
