* pareto_demo.cir -- Enhancement-216: NSGA-II multi-objective / Pareto optimization
*
* A synthetic two-objective problem with a KNOWN analytic Pareto front (the
* Schaffer-1 benchmark): over a single knob px, minimize
*     f1 = px^2      and    f2 = (px - 2)^2
* simultaneously. These conflict -- f1 wants px small, f2 wants px = 2 -- so there
* is no single optimum; the Pareto-optimal set is exactly px in [0, 2], and in
* objective space the front is the curve f2 = (sqrt(f1) - 2)^2. The knob is given
* the wider range [-1, 3] so NSGA-II has to DISCOVER the [0, 2] sub-range.
*
* f1 and f2 are exposed as node voltages so the optimizer can read them with the
* -minimize <expr> objectives; px is a `.param` knob (re-sourced each evaluation).
.param px=1
v1 f1 0 dc 'px*px'
v2 f2 0 dc '(px-2)*(px-2)'
r1 f1 0 1k
r2 f2 0 1k
.control
op
optimize -dparam px 1 -1 3 -analysis op -minimize v(f1) -minimize v(f2) -method nsga2 -maxiter 40 -seed 1
* the front's objective columns are published as vectors pareto1, pareto2.
* Check the whole front against the analytic curve f2 = (sqrt(f1)-2)^2 at full
* precision (the printed front is rounded to 6 significant figures).
let fronterr = maximum(abs(pareto2 - (sqrt(pareto1) - 2)^2))
let npts = length(pareto1)
print fronterr npts
.endc
.end
