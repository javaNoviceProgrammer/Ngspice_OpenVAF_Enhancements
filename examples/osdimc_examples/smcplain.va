// Control model: NO statistics attributes -- .option osdimc must not touch it.
`include "disciplines.vams"

module smcplain(a, b);
  inout a, b;
  electrical a, b;
  parameter real r = 1000.0 from (0:inf);
  analog I(a, b) <+ V(a, b) / r;
endmodule
