// A resistor that owns no `m`: ngspice's `m` is its multiplier's alias.
`include "disciplines.vams"
module cres(p, n);
    inout p, n; electrical p, n;
    parameter real r = 1k from (0:inf);
    analog I(p, n) <+ V(p, n) / r;
endmodule
