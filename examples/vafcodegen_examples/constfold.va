`include "disciplines.vams"

// Enhancement-286: constant-folding an integer operation with no representable
// result evaluated it inside the compiler, so `openvaf-r` itself died with an
// internal error and produced no output. The folder now declines instead.
//
// The same arm also folded add/sub/mul with checked arithmetic and shifted by
// unconstrained distances; both are now wrapping / range-guarded to match what the
// generated code actually computes.
//
// Enhancement-333 UPDATE: division and remainder by a LITERAL zero used to live
// here too, on the reasoning that a runtime zero divisor is accepted so a literal
// one must be. That turned out to be unsafe -- declining to fold left an
// `sdiv x, 0` in the IR, which LLVM treats as undefined behaviour and lowers to a
// trap that killed the host simulator. A literal zero divisor is now a clean
// compile error, so those two lines moved to `constfold_divzero.va`, which asserts
// the diagnostic. A zero divisor reaching the folder through a LOCALPARAM is still
// accepted (it stays a runtime value), and is kept here so this file still
// exercises the div/rem fold path.
//
// Enhancement-334 UPDATE: `1 << 40` was here for the same reason and is rejected for
// the same reason -- an out-of-range shift distance is poison in LLVM and traps. It
// moved to `intub.va`; the largest LEGAL distance is kept here instead.
//
// Enhancement-392 UPDATE: `-2147483648 / -1` used to live here with the note that
// the literal "exceeds i32::MAX, so that literal promotes to REAL and the line is a
// real division". That promotion was itself the defect. `-2147483648` is the
// smallest `integer`, but it parses as unary minus applied to `2147483648`, whose
// magnitude does not fit i32 -- so the operand became a real and the whole
// expression was evaluated in real arithmetic. The same value arriving at runtime
// stayed an integer, so one expression had two meanings. The sign is now folded into
// the literal, which makes this line genuine integer division by -1 -- the one
// operation that really would trap -- so it is rejected by Enhancement-334 and has
// moved to `intub.va` alongside the `(-2147483647 - 1)` spelling of the same thing.
// A representable INT_MIN fold is kept here instead.
module constfold(a, b);
    inout a, b;
    electrical a, b;
    localparam integer lzero = 0;
    integer q, r, s, t, u;
    analog begin
        q = 5 / lzero;              // zero divisor via localparam: still accepted
        r = 5 % lzero;              // ditto for remainder
        s = 2147483647 + 1;         // wraps, must not abort the folder
        t = 1 << 31;                // largest LEGAL shift distance (see below)
        u = -2147483648 / 3;        // INT_MIN as an integer: truncates toward zero
        I(a, b) <+ V(a, b) / 1.0e3 + 0.0 * (q + r + s + t + u);
    end
endmodule
