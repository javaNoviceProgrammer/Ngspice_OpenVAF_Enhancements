`include "disciplines.vams"

// Enhancement-286: constant-folding an integer operation with no representable
// result evaluated it inside the compiler, so `openvaf-r` itself died with an
// internal error and produced no output. The folder now declines instead.
//
// The same arm also folded add/sub/mul with checked arithmetic and shifted by
// unconstrained distances; both are now wrapping / range-guarded to match what the
// generated code actually computes.
//
// Enhancement-333 UPDATE: division and remainder by a LITERAL zero used to live
// here too, on the reasoning that a runtime zero divisor is accepted so a literal
// one must be. That turned out to be unsafe -- declining to fold left an
// `sdiv x, 0` in the IR, which LLVM treats as undefined behaviour and lowers to a
// trap that killed the host simulator. A literal zero divisor is now a clean
// compile error, so those two lines moved to `constfold_divzero.va`, which asserts
// the diagnostic. A zero divisor reaching the folder through a LOCALPARAM is still
// accepted (it stays a runtime value), and is kept here so this file still
// exercises the div/rem fold path.
module constfold(a, b);
    inout a, b;
    electrical a, b;
    localparam integer lzero = 0;
    integer q, r, s, t, u;
    analog begin
        q = 5 / lzero;              // zero divisor via localparam: still accepted
        r = 5 % lzero;              // ditto for remainder
        s = 2147483647 + 1;         // wraps, must not abort the folder
        t = 1 << 40;                // shift distance outside 0..32
        u = -2147483648 / -1;       // i32::MIN / -1 overflows
        I(a, b) <+ V(a, b) / 1.0e3 + 0.0 * (q + r + s + t + u);
    end
endmodule
