`include "disciplines.vams"

// A 5-tap FIR-style weighted sum, exercising array-variable declaration
// (`real [0:4] coeffs;`), indexed write (`coeffs[i] = ...;`), and indexed
// read (`coeffs[i]` in an expression) end-to-end. Coefficients sum to
// 1.0, so V(out) should track V(in) exactly (a closed-form expected
// result, same spirit as bus_examples/bus_buffer.va).
module array_var_fir(in, out);
    input in;
    output out;
    electrical in, out;

    real [0:4] coeffs;

    analog begin
        coeffs[0] = 0.1;
        coeffs[1] = 0.2;
        coeffs[2] = 0.3;
        coeffs[3] = 0.2;
        coeffs[4] = 0.2;
        V(out) <+ (coeffs[0] + coeffs[1] + coeffs[2] + coeffs[3] + coeffs[4]) * V(in);
    end
endmodule
