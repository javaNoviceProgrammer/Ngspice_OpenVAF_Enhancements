// noisecorr_demo.va -- Enhancement-42 / E-528: correlated noise per the LRM.
//
// LRM 4.6.4.6: "Each noise function generates noise which is uncorrelated
// with the noise generated by other functions. Perfectly correlated noise is
// generated by using the OUTPUT OF ONE noise function for more than one noise
// source." So correlation follows the CALL, not the label: one call's output
// routed into several contributions sums as AMPLITUDES at the output, while
// two separate calls stay independent even when they share a name -- the name
// is a reporting label (4.6.4.1: same-named contributions are combined in the
// noise contribution summary), not a correlation key. E-42 first built the
// coherent machinery keyed on the name; the E-528 analysis-noise audit moved
// the key to the call site, which is what these modules pin.
//
// Each module drives its noise through a series a--m--c chain so both
// contributions see a unity transfer to the output.
`include "disciplines.vams"

// ONE call, used twice (the LRM's shared-output idiom): coherent sum
// onoise = |1e-6 + 1e-6| = 2e-6 V/sqrt(Hz) (power-summing reads 1.414e-6)
module ncorr(a, c);
  inout a, c;
  electrical a, c, m;
  real n;
  analog begin
    n = white_noise(1e-12, "src1");
    V(a,m) <+ n;
    V(m,c) <+ n;
  end
endmodule

// distinct calls: independent -> onoise = sqrt(2e-12) = 1.414e-6
module nuncorr(a, c);
  inout a, c;
  electrical a, c, m;
  analog begin
    V(a,m) <+ white_noise(1e-12, "srcA");
    V(m,c) <+ white_noise(1e-12, "srcB");
  end
endmodule

// TWO calls that merely share a label: uncorrelated per 4.6.4.6 -> 1.414e-6
// (they used to be treated as one source and summed coherently to 2e-6; the
// shared label only merges their entries in the contribution summary)
module nlabel(a, c);
  inout a, c;
  electrical a, c, m;
  analog begin
    V(a,m) <+ white_noise(1e-12, "src1");
    V(m,c) <+ white_noise(1e-12, "src1");
  end
endmodule

// one call, second use negated: anti-phase amplitudes CANCEL -> 0
module nanti(a, c);
  inout a, c;
  electrical a, c, m;
  real n;
  analog begin
    n = white_noise(1e-12, "src1");
    V(a,m) <+ n;
    V(m,c) <+ -n;
  end
endmodule

// one call, scaled uses: amplitudes weight linearly -> |2 + 1|*1e-6 = 3e-6
// (power-summing would read sqrt(5)*1e-6 = 2.236e-6)
module nscale(a, c);
  inout a, c;
  electrical a, c, m;
  real n;
  analog begin
    n = white_noise(1e-12, "src1");
    V(a,m) <+ 2.0*n;
    V(m,c) <+ n;
  end
endmodule

// different noise FUNCTIONS never correlate (4.6.4.6), a shared label
// notwithstanding: white + flicker power-sum -> sqrt(2e-12) at f = 1 Hz
module nmix(a, c);
  inout a, c;
  electrical a, c, m;
  analog begin
    V(a,m) <+ white_noise(1e-12, "n1");
    V(m,c) <+ flicker_noise(1e-12, 1.0, "n1");
  end
endmodule
