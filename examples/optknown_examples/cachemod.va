`include "disciplines.vams"
// Enhancement-511: a trivial model, compiled through `pre_osdi -va` so the
// `.option osdicache` decision is observable in the run's own output.
module cachemod(a, b);
  inout a, b; electrical a, b;
  parameter real r = 1000.0;
  analog I(a, b) <+ V(a, b) / r;
endmodule
