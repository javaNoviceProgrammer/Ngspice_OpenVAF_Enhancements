// dtdemo.va -- Enhancement-47: `default_transition (+ transition() signature fix)
//
// LRM: `` `default_transition <time> `` sets the default rise/fall time used
// by transition() filters that omit those arguments; without a directive the
// default is 0 (instantaneous). Previously the directive was a hard error
// ("macro '`default_transition' has not been declared").
//
// Also fixed along the way (pre-existing):
//   * the TRANSITION signature table was one argument short per entry -- a
//     3-argument call `transition(s, td, trise)` CRASHED the compiler
//     (args[3] out of bounds), and 4-argument calls only worked by accident;
//   * the slew/transition tracking loop had a zero DC Jacobian diagonal when
//     its clamp saturated, making the operating point singular whenever the
//     input started a full swing away from the state -- in DC the filter is
//     now the LRM's static identity (y = x), gated on integration enable.
`include "disciplines.vams"
`default_transition 1u

// bare transition(): rise/fall = the directive's 1u.
//
// Enhancement-514: the flip is at 0.5u, not 0. `@(timer(0, ...))` fires during
// the DC solve, so with a flip at t=0 the input has ALREADY changed by the time
// the operating point is computed -- the OP holds 1, and a transient starting
// from it correctly stays at 1 with nothing left to ramp. This module exists to
// check the DIRECTIVE'S RAMP TIME, so the flip belongs inside the transient,
// exactly as dt_delay below already arranges for its own reason.
module dt_bare(a, c);
  inout a, c;
  electrical a, c;
  integer s;
  analog begin
    @(timer(0.5u, 4u)) s = 1 - s;
    V(a,c) <+ transition(s);
  end
endmodule

// delay-only transition(): delayed 0.2u, then ramped with the 1u default.
// (the timer starts at 1u -- a flip at t=0 exercises the absdelay history's
// startup value instead of the ramp, which is not what this check is about)
module dt_delay(a, c);
  inout a, c;
  electrical a, c;
  integer s;
  analog begin
    @(timer(1u, 4u)) s = 1 - s;
    V(a,c) <+ transition(s, 0.2u);
  end
endmodule

// explicit arguments win over the directive; all arities incl. the
// previously-crashing 3-argument form and the 5-argument tol form
module dt_forms(a, c);
  inout a, c;
  electrical a, c;
  integer s;
  analog begin
    @(timer(0.5u, 4u)) s = 1 - s;   // Enhancement-514: see dt_bare
    V(a,c) <+ 0.125*transition(s, 0, 2u)
            + 0.25*transition(s, 0, 2u, 3u)
            + 0.5*transition(s, 0, 2u, 3u, 1e-4);
  end
endmodule
