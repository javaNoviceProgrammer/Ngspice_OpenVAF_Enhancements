* solverannounce: a multi-point sweep must announce the solver ONCE, not per point
* Enhancement-266. Before the fix this printed "Using SPARSE 1.3 as Direct Linear
* Solver" once for every one of the five sweep points (CKTsetup runs per point).
.param rval=1k
r1 1 0 {rval}
v1 1 0 1
.control
sweep rval 1k 5k 1k -output v(1)
.endc
.end
