* arraynode_print.cir -- Enhancement-224: reference array/bus node voltages
* in interactive/print expressions.
*
* Array/bus nodes (Enhancement-221) are named with literal brackets, e.g. a[0].
* The frontend expression parser reads `a[0]` as index 0 of a vector `a`, so
* `print v(a[0])` used to silently fail. E-224 adds a literal-node fallback:
* when the base name is unresolved and a node named `a[0]` exists, it is used.
V0 a[0] 0 dc 1
V1 a[1] 0 dc 3
R1 a[0:1] 2k                  ; -> R1 a[0] a[1] : I = (1-3)/2k = -1mA
R2 a[0] 0 4k
.op
.control
run
print a[0]
print v(a[0])
print v(a[1])
print v(a[0])-v(a[1])
print @r1[i]
.endc
.end
