Enhancement-85 source-location macro check
V1 a 0 1
N1 a 0 slmod
.model slmod srcloc
.control
pre_osdi srcloc.osdi
op
.endc
.end
