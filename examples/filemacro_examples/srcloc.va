// Enhancement-85 (F4): the LRM's predefined source-location macros.
//
// `__FILE__ expands to a string literal holding the source file's name
// (basename -- the expansion is baked into the compiled .osdi, so it must
// stay machine-portable), `__LINE__ to the 1-based line number of the
// occurrence. A use inside a `define body expands at the line of USE (LRM
// 10.7's "current input line number", the C reading) -- the round-4 audit's
// preprocessor implementation replaced the old textual pre-pass, whose
// definition-site expansion this suite used to pin as a deviation.
`include "disciplines.vams"

`define WHERE $strobe("macro-site %s:%0d", `__FILE__, `__LINE__)

module srcloc(a, b);
   inout a, b;
   electrical a, b;
   analog begin
      @(initial_step) begin
         $strobe("direct %s:%0d", `__FILE__, `__LINE__);
         `WHERE;
      end
      V(a,b) <+ V(a,b)/1k;
   end
endmodule
