* absdelay 20x20 mesh benchmark (dc) — 400 nodes
* solver (KLU/SPARSE) selected by run_benchmark.sh
.model dly absdelay_dly (delay=1n)
Ndly0 in g_0_0 dly
Ndly1 g_0_0 g_1_0 dly
Ndly2 g_1_0 g_2_0 dly
Ndly3 g_2_0 g_3_0 dly
Ndly4 g_3_0 g_4_0 dly
Ndly5 g_4_0 g_5_0 dly
Ndly6 g_5_0 g_6_0 dly
Ndly7 g_6_0 g_7_0 dly
Ndly8 g_7_0 g_8_0 dly
Ndly9 g_8_0 g_9_0 dly
Ndly10 g_9_0 g_10_0 dly
Ndly11 g_10_0 g_11_0 dly
Ndly12 g_11_0 g_12_0 dly
Ndly13 g_12_0 g_13_0 dly
Ndly14 g_13_0 g_14_0 dly
Ndly15 g_14_0 g_15_0 dly
Ndly16 g_15_0 g_16_0 dly
Ndly17 g_16_0 g_17_0 dly
Ndly18 g_17_0 g_18_0 dly
Ndly19 g_18_0 g_19_0 dly
Rh_0_0 g_0_0 g_0_1 100k
Rg_0_0 g_0_0 0 10meg
Rh_0_1 g_0_1 g_0_2 100k
Rv_0_1 g_0_1 g_1_1 100k
Rg_0_1 g_0_1 0 10meg
Rh_0_2 g_0_2 g_0_3 100k
Rv_0_2 g_0_2 g_1_2 100k
Rg_0_2 g_0_2 0 10meg
Rh_0_3 g_0_3 g_0_4 100k
Rv_0_3 g_0_3 g_1_3 100k
Rg_0_3 g_0_3 0 10meg
Rh_0_4 g_0_4 g_0_5 100k
Rv_0_4 g_0_4 g_1_4 100k
Rg_0_4 g_0_4 0 10meg
Rh_0_5 g_0_5 g_0_6 100k
Rv_0_5 g_0_5 g_1_5 100k
Rg_0_5 g_0_5 0 10meg
Rh_0_6 g_0_6 g_0_7 100k
Rv_0_6 g_0_6 g_1_6 100k
Rg_0_6 g_0_6 0 10meg
Rh_0_7 g_0_7 g_0_8 100k
Rv_0_7 g_0_7 g_1_7 100k
Rg_0_7 g_0_7 0 10meg
Rh_0_8 g_0_8 g_0_9 100k
Rv_0_8 g_0_8 g_1_8 100k
Rg_0_8 g_0_8 0 10meg
Rh_0_9 g_0_9 g_0_10 100k
Rv_0_9 g_0_9 g_1_9 100k
Rg_0_9 g_0_9 0 10meg
Rh_0_10 g_0_10 g_0_11 100k
Rv_0_10 g_0_10 g_1_10 100k
Rg_0_10 g_0_10 0 10meg
Rh_0_11 g_0_11 g_0_12 100k
Rv_0_11 g_0_11 g_1_11 100k
Rg_0_11 g_0_11 0 10meg
Rh_0_12 g_0_12 g_0_13 100k
Rv_0_12 g_0_12 g_1_12 100k
Rg_0_12 g_0_12 0 10meg
Rh_0_13 g_0_13 g_0_14 100k
Rv_0_13 g_0_13 g_1_13 100k
Rg_0_13 g_0_13 0 10meg
Rh_0_14 g_0_14 g_0_15 100k
Rv_0_14 g_0_14 g_1_14 100k
Rg_0_14 g_0_14 0 10meg
Rh_0_15 g_0_15 g_0_16 100k
Rv_0_15 g_0_15 g_1_15 100k
Rg_0_15 g_0_15 0 10meg
Rh_0_16 g_0_16 g_0_17 100k
Rv_0_16 g_0_16 g_1_16 100k
Rg_0_16 g_0_16 0 10meg
Rh_0_17 g_0_17 g_0_18 100k
Rv_0_17 g_0_17 g_1_17 100k
Rg_0_17 g_0_17 0 10meg
Rh_0_18 g_0_18 g_0_19 100k
Rv_0_18 g_0_18 g_1_18 100k
Rg_0_18 g_0_18 0 10meg
Rv_0_19 g_0_19 g_1_19 100k
Rg_0_19 g_0_19 0 10meg
Rh_1_0 g_1_0 g_1_1 100k
Rg_1_0 g_1_0 0 10meg
Rh_1_1 g_1_1 g_1_2 100k
Rv_1_1 g_1_1 g_2_1 100k
Rg_1_1 g_1_1 0 10meg
Rh_1_2 g_1_2 g_1_3 100k
Rv_1_2 g_1_2 g_2_2 100k
Rg_1_2 g_1_2 0 10meg
Rh_1_3 g_1_3 g_1_4 100k
Rv_1_3 g_1_3 g_2_3 100k
Rg_1_3 g_1_3 0 10meg
Rh_1_4 g_1_4 g_1_5 100k
Rv_1_4 g_1_4 g_2_4 100k
Rg_1_4 g_1_4 0 10meg
Rh_1_5 g_1_5 g_1_6 100k
Rv_1_5 g_1_5 g_2_5 100k
Rg_1_5 g_1_5 0 10meg
Rh_1_6 g_1_6 g_1_7 100k
Rv_1_6 g_1_6 g_2_6 100k
Rg_1_6 g_1_6 0 10meg
Rh_1_7 g_1_7 g_1_8 100k
Rv_1_7 g_1_7 g_2_7 100k
Rg_1_7 g_1_7 0 10meg
Rh_1_8 g_1_8 g_1_9 100k
Rv_1_8 g_1_8 g_2_8 100k
Rg_1_8 g_1_8 0 10meg
Rh_1_9 g_1_9 g_1_10 100k
Rv_1_9 g_1_9 g_2_9 100k
Rg_1_9 g_1_9 0 10meg
Rh_1_10 g_1_10 g_1_11 100k
Rv_1_10 g_1_10 g_2_10 100k
Rg_1_10 g_1_10 0 10meg
Rh_1_11 g_1_11 g_1_12 100k
Rv_1_11 g_1_11 g_2_11 100k
Rg_1_11 g_1_11 0 10meg
Rh_1_12 g_1_12 g_1_13 100k
Rv_1_12 g_1_12 g_2_12 100k
Rg_1_12 g_1_12 0 10meg
Rh_1_13 g_1_13 g_1_14 100k
Rv_1_13 g_1_13 g_2_13 100k
Rg_1_13 g_1_13 0 10meg
Rh_1_14 g_1_14 g_1_15 100k
Rv_1_14 g_1_14 g_2_14 100k
Rg_1_14 g_1_14 0 10meg
Rh_1_15 g_1_15 g_1_16 100k
Rv_1_15 g_1_15 g_2_15 100k
Rg_1_15 g_1_15 0 10meg
Rh_1_16 g_1_16 g_1_17 100k
Rv_1_16 g_1_16 g_2_16 100k
Rg_1_16 g_1_16 0 10meg
Rh_1_17 g_1_17 g_1_18 100k
Rv_1_17 g_1_17 g_2_17 100k
Rg_1_17 g_1_17 0 10meg
Rh_1_18 g_1_18 g_1_19 100k
Rv_1_18 g_1_18 g_2_18 100k
Rg_1_18 g_1_18 0 10meg
Rv_1_19 g_1_19 g_2_19 100k
Rg_1_19 g_1_19 0 10meg
Rh_2_0 g_2_0 g_2_1 100k
Rg_2_0 g_2_0 0 10meg
Rh_2_1 g_2_1 g_2_2 100k
Rv_2_1 g_2_1 g_3_1 100k
Rg_2_1 g_2_1 0 10meg
Rh_2_2 g_2_2 g_2_3 100k
Rv_2_2 g_2_2 g_3_2 100k
Rg_2_2 g_2_2 0 10meg
Rh_2_3 g_2_3 g_2_4 100k
Rv_2_3 g_2_3 g_3_3 100k
Rg_2_3 g_2_3 0 10meg
Rh_2_4 g_2_4 g_2_5 100k
Rv_2_4 g_2_4 g_3_4 100k
Rg_2_4 g_2_4 0 10meg
Rh_2_5 g_2_5 g_2_6 100k
Rv_2_5 g_2_5 g_3_5 100k
Rg_2_5 g_2_5 0 10meg
Rh_2_6 g_2_6 g_2_7 100k
Rv_2_6 g_2_6 g_3_6 100k
Rg_2_6 g_2_6 0 10meg
Rh_2_7 g_2_7 g_2_8 100k
Rv_2_7 g_2_7 g_3_7 100k
Rg_2_7 g_2_7 0 10meg
Rh_2_8 g_2_8 g_2_9 100k
Rv_2_8 g_2_8 g_3_8 100k
Rg_2_8 g_2_8 0 10meg
Rh_2_9 g_2_9 g_2_10 100k
Rv_2_9 g_2_9 g_3_9 100k
Rg_2_9 g_2_9 0 10meg
Rh_2_10 g_2_10 g_2_11 100k
Rv_2_10 g_2_10 g_3_10 100k
Rg_2_10 g_2_10 0 10meg
Rh_2_11 g_2_11 g_2_12 100k
Rv_2_11 g_2_11 g_3_11 100k
Rg_2_11 g_2_11 0 10meg
Rh_2_12 g_2_12 g_2_13 100k
Rv_2_12 g_2_12 g_3_12 100k
Rg_2_12 g_2_12 0 10meg
Rh_2_13 g_2_13 g_2_14 100k
Rv_2_13 g_2_13 g_3_13 100k
Rg_2_13 g_2_13 0 10meg
Rh_2_14 g_2_14 g_2_15 100k
Rv_2_14 g_2_14 g_3_14 100k
Rg_2_14 g_2_14 0 10meg
Rh_2_15 g_2_15 g_2_16 100k
Rv_2_15 g_2_15 g_3_15 100k
Rg_2_15 g_2_15 0 10meg
Rh_2_16 g_2_16 g_2_17 100k
Rv_2_16 g_2_16 g_3_16 100k
Rg_2_16 g_2_16 0 10meg
Rh_2_17 g_2_17 g_2_18 100k
Rv_2_17 g_2_17 g_3_17 100k
Rg_2_17 g_2_17 0 10meg
Rh_2_18 g_2_18 g_2_19 100k
Rv_2_18 g_2_18 g_3_18 100k
Rg_2_18 g_2_18 0 10meg
Rv_2_19 g_2_19 g_3_19 100k
Rg_2_19 g_2_19 0 10meg
Rh_3_0 g_3_0 g_3_1 100k
Rg_3_0 g_3_0 0 10meg
Rh_3_1 g_3_1 g_3_2 100k
Rv_3_1 g_3_1 g_4_1 100k
Rg_3_1 g_3_1 0 10meg
Rh_3_2 g_3_2 g_3_3 100k
Rv_3_2 g_3_2 g_4_2 100k
Rg_3_2 g_3_2 0 10meg
Rh_3_3 g_3_3 g_3_4 100k
Rv_3_3 g_3_3 g_4_3 100k
Rg_3_3 g_3_3 0 10meg
Rh_3_4 g_3_4 g_3_5 100k
Rv_3_4 g_3_4 g_4_4 100k
Rg_3_4 g_3_4 0 10meg
Rh_3_5 g_3_5 g_3_6 100k
Rv_3_5 g_3_5 g_4_5 100k
Rg_3_5 g_3_5 0 10meg
Rh_3_6 g_3_6 g_3_7 100k
Rv_3_6 g_3_6 g_4_6 100k
Rg_3_6 g_3_6 0 10meg
Rh_3_7 g_3_7 g_3_8 100k
Rv_3_7 g_3_7 g_4_7 100k
Rg_3_7 g_3_7 0 10meg
Rh_3_8 g_3_8 g_3_9 100k
Rv_3_8 g_3_8 g_4_8 100k
Rg_3_8 g_3_8 0 10meg
Rh_3_9 g_3_9 g_3_10 100k
Rv_3_9 g_3_9 g_4_9 100k
Rg_3_9 g_3_9 0 10meg
Rh_3_10 g_3_10 g_3_11 100k
Rv_3_10 g_3_10 g_4_10 100k
Rg_3_10 g_3_10 0 10meg
Rh_3_11 g_3_11 g_3_12 100k
Rv_3_11 g_3_11 g_4_11 100k
Rg_3_11 g_3_11 0 10meg
Rh_3_12 g_3_12 g_3_13 100k
Rv_3_12 g_3_12 g_4_12 100k
Rg_3_12 g_3_12 0 10meg
Rh_3_13 g_3_13 g_3_14 100k
Rv_3_13 g_3_13 g_4_13 100k
Rg_3_13 g_3_13 0 10meg
Rh_3_14 g_3_14 g_3_15 100k
Rv_3_14 g_3_14 g_4_14 100k
Rg_3_14 g_3_14 0 10meg
Rh_3_15 g_3_15 g_3_16 100k
Rv_3_15 g_3_15 g_4_15 100k
Rg_3_15 g_3_15 0 10meg
Rh_3_16 g_3_16 g_3_17 100k
Rv_3_16 g_3_16 g_4_16 100k
Rg_3_16 g_3_16 0 10meg
Rh_3_17 g_3_17 g_3_18 100k
Rv_3_17 g_3_17 g_4_17 100k
Rg_3_17 g_3_17 0 10meg
Rh_3_18 g_3_18 g_3_19 100k
Rv_3_18 g_3_18 g_4_18 100k
Rg_3_18 g_3_18 0 10meg
Rv_3_19 g_3_19 g_4_19 100k
Rg_3_19 g_3_19 0 10meg
Rh_4_0 g_4_0 g_4_1 100k
Rg_4_0 g_4_0 0 10meg
Rh_4_1 g_4_1 g_4_2 100k
Rv_4_1 g_4_1 g_5_1 100k
Rg_4_1 g_4_1 0 10meg
Rh_4_2 g_4_2 g_4_3 100k
Rv_4_2 g_4_2 g_5_2 100k
Rg_4_2 g_4_2 0 10meg
Rh_4_3 g_4_3 g_4_4 100k
Rv_4_3 g_4_3 g_5_3 100k
Rg_4_3 g_4_3 0 10meg
Rh_4_4 g_4_4 g_4_5 100k
Rv_4_4 g_4_4 g_5_4 100k
Rg_4_4 g_4_4 0 10meg
Rh_4_5 g_4_5 g_4_6 100k
Rv_4_5 g_4_5 g_5_5 100k
Rg_4_5 g_4_5 0 10meg
Rh_4_6 g_4_6 g_4_7 100k
Rv_4_6 g_4_6 g_5_6 100k
Rg_4_6 g_4_6 0 10meg
Rh_4_7 g_4_7 g_4_8 100k
Rv_4_7 g_4_7 g_5_7 100k
Rg_4_7 g_4_7 0 10meg
Rh_4_8 g_4_8 g_4_9 100k
Rv_4_8 g_4_8 g_5_8 100k
Rg_4_8 g_4_8 0 10meg
Rh_4_9 g_4_9 g_4_10 100k
Rv_4_9 g_4_9 g_5_9 100k
Rg_4_9 g_4_9 0 10meg
Rh_4_10 g_4_10 g_4_11 100k
Rv_4_10 g_4_10 g_5_10 100k
Rg_4_10 g_4_10 0 10meg
Rh_4_11 g_4_11 g_4_12 100k
Rv_4_11 g_4_11 g_5_11 100k
Rg_4_11 g_4_11 0 10meg
Rh_4_12 g_4_12 g_4_13 100k
Rv_4_12 g_4_12 g_5_12 100k
Rg_4_12 g_4_12 0 10meg
Rh_4_13 g_4_13 g_4_14 100k
Rv_4_13 g_4_13 g_5_13 100k
Rg_4_13 g_4_13 0 10meg
Rh_4_14 g_4_14 g_4_15 100k
Rv_4_14 g_4_14 g_5_14 100k
Rg_4_14 g_4_14 0 10meg
Rh_4_15 g_4_15 g_4_16 100k
Rv_4_15 g_4_15 g_5_15 100k
Rg_4_15 g_4_15 0 10meg
Rh_4_16 g_4_16 g_4_17 100k
Rv_4_16 g_4_16 g_5_16 100k
Rg_4_16 g_4_16 0 10meg
Rh_4_17 g_4_17 g_4_18 100k
Rv_4_17 g_4_17 g_5_17 100k
Rg_4_17 g_4_17 0 10meg
Rh_4_18 g_4_18 g_4_19 100k
Rv_4_18 g_4_18 g_5_18 100k
Rg_4_18 g_4_18 0 10meg
Rv_4_19 g_4_19 g_5_19 100k
Rg_4_19 g_4_19 0 10meg
Rh_5_0 g_5_0 g_5_1 100k
Rg_5_0 g_5_0 0 10meg
Rh_5_1 g_5_1 g_5_2 100k
Rv_5_1 g_5_1 g_6_1 100k
Rg_5_1 g_5_1 0 10meg
Rh_5_2 g_5_2 g_5_3 100k
Rv_5_2 g_5_2 g_6_2 100k
Rg_5_2 g_5_2 0 10meg
Rh_5_3 g_5_3 g_5_4 100k
Rv_5_3 g_5_3 g_6_3 100k
Rg_5_3 g_5_3 0 10meg
Rh_5_4 g_5_4 g_5_5 100k
Rv_5_4 g_5_4 g_6_4 100k
Rg_5_4 g_5_4 0 10meg
Rh_5_5 g_5_5 g_5_6 100k
Rv_5_5 g_5_5 g_6_5 100k
Rg_5_5 g_5_5 0 10meg
Rh_5_6 g_5_6 g_5_7 100k
Rv_5_6 g_5_6 g_6_6 100k
Rg_5_6 g_5_6 0 10meg
Rh_5_7 g_5_7 g_5_8 100k
Rv_5_7 g_5_7 g_6_7 100k
Rg_5_7 g_5_7 0 10meg
Rh_5_8 g_5_8 g_5_9 100k
Rv_5_8 g_5_8 g_6_8 100k
Rg_5_8 g_5_8 0 10meg
Rh_5_9 g_5_9 g_5_10 100k
Rv_5_9 g_5_9 g_6_9 100k
Rg_5_9 g_5_9 0 10meg
Rh_5_10 g_5_10 g_5_11 100k
Rv_5_10 g_5_10 g_6_10 100k
Rg_5_10 g_5_10 0 10meg
Rh_5_11 g_5_11 g_5_12 100k
Rv_5_11 g_5_11 g_6_11 100k
Rg_5_11 g_5_11 0 10meg
Rh_5_12 g_5_12 g_5_13 100k
Rv_5_12 g_5_12 g_6_12 100k
Rg_5_12 g_5_12 0 10meg
Rh_5_13 g_5_13 g_5_14 100k
Rv_5_13 g_5_13 g_6_13 100k
Rg_5_13 g_5_13 0 10meg
Rh_5_14 g_5_14 g_5_15 100k
Rv_5_14 g_5_14 g_6_14 100k
Rg_5_14 g_5_14 0 10meg
Rh_5_15 g_5_15 g_5_16 100k
Rv_5_15 g_5_15 g_6_15 100k
Rg_5_15 g_5_15 0 10meg
Rh_5_16 g_5_16 g_5_17 100k
Rv_5_16 g_5_16 g_6_16 100k
Rg_5_16 g_5_16 0 10meg
Rh_5_17 g_5_17 g_5_18 100k
Rv_5_17 g_5_17 g_6_17 100k
Rg_5_17 g_5_17 0 10meg
Rh_5_18 g_5_18 g_5_19 100k
Rv_5_18 g_5_18 g_6_18 100k
Rg_5_18 g_5_18 0 10meg
Rv_5_19 g_5_19 g_6_19 100k
Rg_5_19 g_5_19 0 10meg
Rh_6_0 g_6_0 g_6_1 100k
Rg_6_0 g_6_0 0 10meg
Rh_6_1 g_6_1 g_6_2 100k
Rv_6_1 g_6_1 g_7_1 100k
Rg_6_1 g_6_1 0 10meg
Rh_6_2 g_6_2 g_6_3 100k
Rv_6_2 g_6_2 g_7_2 100k
Rg_6_2 g_6_2 0 10meg
Rh_6_3 g_6_3 g_6_4 100k
Rv_6_3 g_6_3 g_7_3 100k
Rg_6_3 g_6_3 0 10meg
Rh_6_4 g_6_4 g_6_5 100k
Rv_6_4 g_6_4 g_7_4 100k
Rg_6_4 g_6_4 0 10meg
Rh_6_5 g_6_5 g_6_6 100k
Rv_6_5 g_6_5 g_7_5 100k
Rg_6_5 g_6_5 0 10meg
Rh_6_6 g_6_6 g_6_7 100k
Rv_6_6 g_6_6 g_7_6 100k
Rg_6_6 g_6_6 0 10meg
Rh_6_7 g_6_7 g_6_8 100k
Rv_6_7 g_6_7 g_7_7 100k
Rg_6_7 g_6_7 0 10meg
Rh_6_8 g_6_8 g_6_9 100k
Rv_6_8 g_6_8 g_7_8 100k
Rg_6_8 g_6_8 0 10meg
Rh_6_9 g_6_9 g_6_10 100k
Rv_6_9 g_6_9 g_7_9 100k
Rg_6_9 g_6_9 0 10meg
Rh_6_10 g_6_10 g_6_11 100k
Rv_6_10 g_6_10 g_7_10 100k
Rg_6_10 g_6_10 0 10meg
Rh_6_11 g_6_11 g_6_12 100k
Rv_6_11 g_6_11 g_7_11 100k
Rg_6_11 g_6_11 0 10meg
Rh_6_12 g_6_12 g_6_13 100k
Rv_6_12 g_6_12 g_7_12 100k
Rg_6_12 g_6_12 0 10meg
Rh_6_13 g_6_13 g_6_14 100k
Rv_6_13 g_6_13 g_7_13 100k
Rg_6_13 g_6_13 0 10meg
Rh_6_14 g_6_14 g_6_15 100k
Rv_6_14 g_6_14 g_7_14 100k
Rg_6_14 g_6_14 0 10meg
Rh_6_15 g_6_15 g_6_16 100k
Rv_6_15 g_6_15 g_7_15 100k
Rg_6_15 g_6_15 0 10meg
Rh_6_16 g_6_16 g_6_17 100k
Rv_6_16 g_6_16 g_7_16 100k
Rg_6_16 g_6_16 0 10meg
Rh_6_17 g_6_17 g_6_18 100k
Rv_6_17 g_6_17 g_7_17 100k
Rg_6_17 g_6_17 0 10meg
Rh_6_18 g_6_18 g_6_19 100k
Rv_6_18 g_6_18 g_7_18 100k
Rg_6_18 g_6_18 0 10meg
Rv_6_19 g_6_19 g_7_19 100k
Rg_6_19 g_6_19 0 10meg
Rh_7_0 g_7_0 g_7_1 100k
Rg_7_0 g_7_0 0 10meg
Rh_7_1 g_7_1 g_7_2 100k
Rv_7_1 g_7_1 g_8_1 100k
Rg_7_1 g_7_1 0 10meg
Rh_7_2 g_7_2 g_7_3 100k
Rv_7_2 g_7_2 g_8_2 100k
Rg_7_2 g_7_2 0 10meg
Rh_7_3 g_7_3 g_7_4 100k
Rv_7_3 g_7_3 g_8_3 100k
Rg_7_3 g_7_3 0 10meg
Rh_7_4 g_7_4 g_7_5 100k
Rv_7_4 g_7_4 g_8_4 100k
Rg_7_4 g_7_4 0 10meg
Rh_7_5 g_7_5 g_7_6 100k
Rv_7_5 g_7_5 g_8_5 100k
Rg_7_5 g_7_5 0 10meg
Rh_7_6 g_7_6 g_7_7 100k
Rv_7_6 g_7_6 g_8_6 100k
Rg_7_6 g_7_6 0 10meg
Rh_7_7 g_7_7 g_7_8 100k
Rv_7_7 g_7_7 g_8_7 100k
Rg_7_7 g_7_7 0 10meg
Rh_7_8 g_7_8 g_7_9 100k
Rv_7_8 g_7_8 g_8_8 100k
Rg_7_8 g_7_8 0 10meg
Rh_7_9 g_7_9 g_7_10 100k
Rv_7_9 g_7_9 g_8_9 100k
Rg_7_9 g_7_9 0 10meg
Rh_7_10 g_7_10 g_7_11 100k
Rv_7_10 g_7_10 g_8_10 100k
Rg_7_10 g_7_10 0 10meg
Rh_7_11 g_7_11 g_7_12 100k
Rv_7_11 g_7_11 g_8_11 100k
Rg_7_11 g_7_11 0 10meg
Rh_7_12 g_7_12 g_7_13 100k
Rv_7_12 g_7_12 g_8_12 100k
Rg_7_12 g_7_12 0 10meg
Rh_7_13 g_7_13 g_7_14 100k
Rv_7_13 g_7_13 g_8_13 100k
Rg_7_13 g_7_13 0 10meg
Rh_7_14 g_7_14 g_7_15 100k
Rv_7_14 g_7_14 g_8_14 100k
Rg_7_14 g_7_14 0 10meg
Rh_7_15 g_7_15 g_7_16 100k
Rv_7_15 g_7_15 g_8_15 100k
Rg_7_15 g_7_15 0 10meg
Rh_7_16 g_7_16 g_7_17 100k
Rv_7_16 g_7_16 g_8_16 100k
Rg_7_16 g_7_16 0 10meg
Rh_7_17 g_7_17 g_7_18 100k
Rv_7_17 g_7_17 g_8_17 100k
Rg_7_17 g_7_17 0 10meg
Rh_7_18 g_7_18 g_7_19 100k
Rv_7_18 g_7_18 g_8_18 100k
Rg_7_18 g_7_18 0 10meg
Rv_7_19 g_7_19 g_8_19 100k
Rg_7_19 g_7_19 0 10meg
Rh_8_0 g_8_0 g_8_1 100k
Rg_8_0 g_8_0 0 10meg
Rh_8_1 g_8_1 g_8_2 100k
Rv_8_1 g_8_1 g_9_1 100k
Rg_8_1 g_8_1 0 10meg
Rh_8_2 g_8_2 g_8_3 100k
Rv_8_2 g_8_2 g_9_2 100k
Rg_8_2 g_8_2 0 10meg
Rh_8_3 g_8_3 g_8_4 100k
Rv_8_3 g_8_3 g_9_3 100k
Rg_8_3 g_8_3 0 10meg
Rh_8_4 g_8_4 g_8_5 100k
Rv_8_4 g_8_4 g_9_4 100k
Rg_8_4 g_8_4 0 10meg
Rh_8_5 g_8_5 g_8_6 100k
Rv_8_5 g_8_5 g_9_5 100k
Rg_8_5 g_8_5 0 10meg
Rh_8_6 g_8_6 g_8_7 100k
Rv_8_6 g_8_6 g_9_6 100k
Rg_8_6 g_8_6 0 10meg
Rh_8_7 g_8_7 g_8_8 100k
Rv_8_7 g_8_7 g_9_7 100k
Rg_8_7 g_8_7 0 10meg
Rh_8_8 g_8_8 g_8_9 100k
Rv_8_8 g_8_8 g_9_8 100k
Rg_8_8 g_8_8 0 10meg
Rh_8_9 g_8_9 g_8_10 100k
Rv_8_9 g_8_9 g_9_9 100k
Rg_8_9 g_8_9 0 10meg
Rh_8_10 g_8_10 g_8_11 100k
Rv_8_10 g_8_10 g_9_10 100k
Rg_8_10 g_8_10 0 10meg
Rh_8_11 g_8_11 g_8_12 100k
Rv_8_11 g_8_11 g_9_11 100k
Rg_8_11 g_8_11 0 10meg
Rh_8_12 g_8_12 g_8_13 100k
Rv_8_12 g_8_12 g_9_12 100k
Rg_8_12 g_8_12 0 10meg
Rh_8_13 g_8_13 g_8_14 100k
Rv_8_13 g_8_13 g_9_13 100k
Rg_8_13 g_8_13 0 10meg
Rh_8_14 g_8_14 g_8_15 100k
Rv_8_14 g_8_14 g_9_14 100k
Rg_8_14 g_8_14 0 10meg
Rh_8_15 g_8_15 g_8_16 100k
Rv_8_15 g_8_15 g_9_15 100k
Rg_8_15 g_8_15 0 10meg
Rh_8_16 g_8_16 g_8_17 100k
Rv_8_16 g_8_16 g_9_16 100k
Rg_8_16 g_8_16 0 10meg
Rh_8_17 g_8_17 g_8_18 100k
Rv_8_17 g_8_17 g_9_17 100k
Rg_8_17 g_8_17 0 10meg
Rh_8_18 g_8_18 g_8_19 100k
Rv_8_18 g_8_18 g_9_18 100k
Rg_8_18 g_8_18 0 10meg
Rv_8_19 g_8_19 g_9_19 100k
Rg_8_19 g_8_19 0 10meg
Rh_9_0 g_9_0 g_9_1 100k
Rg_9_0 g_9_0 0 10meg
Rh_9_1 g_9_1 g_9_2 100k
Rv_9_1 g_9_1 g_10_1 100k
Rg_9_1 g_9_1 0 10meg
Rh_9_2 g_9_2 g_9_3 100k
Rv_9_2 g_9_2 g_10_2 100k
Rg_9_2 g_9_2 0 10meg
Rh_9_3 g_9_3 g_9_4 100k
Rv_9_3 g_9_3 g_10_3 100k
Rg_9_3 g_9_3 0 10meg
Rh_9_4 g_9_4 g_9_5 100k
Rv_9_4 g_9_4 g_10_4 100k
Rg_9_4 g_9_4 0 10meg
Rh_9_5 g_9_5 g_9_6 100k
Rv_9_5 g_9_5 g_10_5 100k
Rg_9_5 g_9_5 0 10meg
Rh_9_6 g_9_6 g_9_7 100k
Rv_9_6 g_9_6 g_10_6 100k
Rg_9_6 g_9_6 0 10meg
Rh_9_7 g_9_7 g_9_8 100k
Rv_9_7 g_9_7 g_10_7 100k
Rg_9_7 g_9_7 0 10meg
Rh_9_8 g_9_8 g_9_9 100k
Rv_9_8 g_9_8 g_10_8 100k
Rg_9_8 g_9_8 0 10meg
Rh_9_9 g_9_9 g_9_10 100k
Rv_9_9 g_9_9 g_10_9 100k
Rg_9_9 g_9_9 0 10meg
Rh_9_10 g_9_10 g_9_11 100k
Rv_9_10 g_9_10 g_10_10 100k
Rg_9_10 g_9_10 0 10meg
Rh_9_11 g_9_11 g_9_12 100k
Rv_9_11 g_9_11 g_10_11 100k
Rg_9_11 g_9_11 0 10meg
Rh_9_12 g_9_12 g_9_13 100k
Rv_9_12 g_9_12 g_10_12 100k
Rg_9_12 g_9_12 0 10meg
Rh_9_13 g_9_13 g_9_14 100k
Rv_9_13 g_9_13 g_10_13 100k
Rg_9_13 g_9_13 0 10meg
Rh_9_14 g_9_14 g_9_15 100k
Rv_9_14 g_9_14 g_10_14 100k
Rg_9_14 g_9_14 0 10meg
Rh_9_15 g_9_15 g_9_16 100k
Rv_9_15 g_9_15 g_10_15 100k
Rg_9_15 g_9_15 0 10meg
Rh_9_16 g_9_16 g_9_17 100k
Rv_9_16 g_9_16 g_10_16 100k
Rg_9_16 g_9_16 0 10meg
Rh_9_17 g_9_17 g_9_18 100k
Rv_9_17 g_9_17 g_10_17 100k
Rg_9_17 g_9_17 0 10meg
Rh_9_18 g_9_18 g_9_19 100k
Rv_9_18 g_9_18 g_10_18 100k
Rg_9_18 g_9_18 0 10meg
Rv_9_19 g_9_19 g_10_19 100k
Rg_9_19 g_9_19 0 10meg
Rh_10_0 g_10_0 g_10_1 100k
Rg_10_0 g_10_0 0 10meg
Rh_10_1 g_10_1 g_10_2 100k
Rv_10_1 g_10_1 g_11_1 100k
Rg_10_1 g_10_1 0 10meg
Rh_10_2 g_10_2 g_10_3 100k
Rv_10_2 g_10_2 g_11_2 100k
Rg_10_2 g_10_2 0 10meg
Rh_10_3 g_10_3 g_10_4 100k
Rv_10_3 g_10_3 g_11_3 100k
Rg_10_3 g_10_3 0 10meg
Rh_10_4 g_10_4 g_10_5 100k
Rv_10_4 g_10_4 g_11_4 100k
Rg_10_4 g_10_4 0 10meg
Rh_10_5 g_10_5 g_10_6 100k
Rv_10_5 g_10_5 g_11_5 100k
Rg_10_5 g_10_5 0 10meg
Rh_10_6 g_10_6 g_10_7 100k
Rv_10_6 g_10_6 g_11_6 100k
Rg_10_6 g_10_6 0 10meg
Rh_10_7 g_10_7 g_10_8 100k
Rv_10_7 g_10_7 g_11_7 100k
Rg_10_7 g_10_7 0 10meg
Rh_10_8 g_10_8 g_10_9 100k
Rv_10_8 g_10_8 g_11_8 100k
Rg_10_8 g_10_8 0 10meg
Rh_10_9 g_10_9 g_10_10 100k
Rv_10_9 g_10_9 g_11_9 100k
Rg_10_9 g_10_9 0 10meg
Rh_10_10 g_10_10 g_10_11 100k
Rv_10_10 g_10_10 g_11_10 100k
Rg_10_10 g_10_10 0 10meg
Rh_10_11 g_10_11 g_10_12 100k
Rv_10_11 g_10_11 g_11_11 100k
Rg_10_11 g_10_11 0 10meg
Rh_10_12 g_10_12 g_10_13 100k
Rv_10_12 g_10_12 g_11_12 100k
Rg_10_12 g_10_12 0 10meg
Rh_10_13 g_10_13 g_10_14 100k
Rv_10_13 g_10_13 g_11_13 100k
Rg_10_13 g_10_13 0 10meg
Rh_10_14 g_10_14 g_10_15 100k
Rv_10_14 g_10_14 g_11_14 100k
Rg_10_14 g_10_14 0 10meg
Rh_10_15 g_10_15 g_10_16 100k
Rv_10_15 g_10_15 g_11_15 100k
Rg_10_15 g_10_15 0 10meg
Rh_10_16 g_10_16 g_10_17 100k
Rv_10_16 g_10_16 g_11_16 100k
Rg_10_16 g_10_16 0 10meg
Rh_10_17 g_10_17 g_10_18 100k
Rv_10_17 g_10_17 g_11_17 100k
Rg_10_17 g_10_17 0 10meg
Rh_10_18 g_10_18 g_10_19 100k
Rv_10_18 g_10_18 g_11_18 100k
Rg_10_18 g_10_18 0 10meg
Rv_10_19 g_10_19 g_11_19 100k
Rg_10_19 g_10_19 0 10meg
Rh_11_0 g_11_0 g_11_1 100k
Rg_11_0 g_11_0 0 10meg
Rh_11_1 g_11_1 g_11_2 100k
Rv_11_1 g_11_1 g_12_1 100k
Rg_11_1 g_11_1 0 10meg
Rh_11_2 g_11_2 g_11_3 100k
Rv_11_2 g_11_2 g_12_2 100k
Rg_11_2 g_11_2 0 10meg
Rh_11_3 g_11_3 g_11_4 100k
Rv_11_3 g_11_3 g_12_3 100k
Rg_11_3 g_11_3 0 10meg
Rh_11_4 g_11_4 g_11_5 100k
Rv_11_4 g_11_4 g_12_4 100k
Rg_11_4 g_11_4 0 10meg
Rh_11_5 g_11_5 g_11_6 100k
Rv_11_5 g_11_5 g_12_5 100k
Rg_11_5 g_11_5 0 10meg
Rh_11_6 g_11_6 g_11_7 100k
Rv_11_6 g_11_6 g_12_6 100k
Rg_11_6 g_11_6 0 10meg
Rh_11_7 g_11_7 g_11_8 100k
Rv_11_7 g_11_7 g_12_7 100k
Rg_11_7 g_11_7 0 10meg
Rh_11_8 g_11_8 g_11_9 100k
Rv_11_8 g_11_8 g_12_8 100k
Rg_11_8 g_11_8 0 10meg
Rh_11_9 g_11_9 g_11_10 100k
Rv_11_9 g_11_9 g_12_9 100k
Rg_11_9 g_11_9 0 10meg
Rh_11_10 g_11_10 g_11_11 100k
Rv_11_10 g_11_10 g_12_10 100k
Rg_11_10 g_11_10 0 10meg
Rh_11_11 g_11_11 g_11_12 100k
Rv_11_11 g_11_11 g_12_11 100k
Rg_11_11 g_11_11 0 10meg
Rh_11_12 g_11_12 g_11_13 100k
Rv_11_12 g_11_12 g_12_12 100k
Rg_11_12 g_11_12 0 10meg
Rh_11_13 g_11_13 g_11_14 100k
Rv_11_13 g_11_13 g_12_13 100k
Rg_11_13 g_11_13 0 10meg
Rh_11_14 g_11_14 g_11_15 100k
Rv_11_14 g_11_14 g_12_14 100k
Rg_11_14 g_11_14 0 10meg
Rh_11_15 g_11_15 g_11_16 100k
Rv_11_15 g_11_15 g_12_15 100k
Rg_11_15 g_11_15 0 10meg
Rh_11_16 g_11_16 g_11_17 100k
Rv_11_16 g_11_16 g_12_16 100k
Rg_11_16 g_11_16 0 10meg
Rh_11_17 g_11_17 g_11_18 100k
Rv_11_17 g_11_17 g_12_17 100k
Rg_11_17 g_11_17 0 10meg
Rh_11_18 g_11_18 g_11_19 100k
Rv_11_18 g_11_18 g_12_18 100k
Rg_11_18 g_11_18 0 10meg
Rv_11_19 g_11_19 g_12_19 100k
Rg_11_19 g_11_19 0 10meg
Rh_12_0 g_12_0 g_12_1 100k
Rg_12_0 g_12_0 0 10meg
Rh_12_1 g_12_1 g_12_2 100k
Rv_12_1 g_12_1 g_13_1 100k
Rg_12_1 g_12_1 0 10meg
Rh_12_2 g_12_2 g_12_3 100k
Rv_12_2 g_12_2 g_13_2 100k
Rg_12_2 g_12_2 0 10meg
Rh_12_3 g_12_3 g_12_4 100k
Rv_12_3 g_12_3 g_13_3 100k
Rg_12_3 g_12_3 0 10meg
Rh_12_4 g_12_4 g_12_5 100k
Rv_12_4 g_12_4 g_13_4 100k
Rg_12_4 g_12_4 0 10meg
Rh_12_5 g_12_5 g_12_6 100k
Rv_12_5 g_12_5 g_13_5 100k
Rg_12_5 g_12_5 0 10meg
Rh_12_6 g_12_6 g_12_7 100k
Rv_12_6 g_12_6 g_13_6 100k
Rg_12_6 g_12_6 0 10meg
Rh_12_7 g_12_7 g_12_8 100k
Rv_12_7 g_12_7 g_13_7 100k
Rg_12_7 g_12_7 0 10meg
Rh_12_8 g_12_8 g_12_9 100k
Rv_12_8 g_12_8 g_13_8 100k
Rg_12_8 g_12_8 0 10meg
Rh_12_9 g_12_9 g_12_10 100k
Rv_12_9 g_12_9 g_13_9 100k
Rg_12_9 g_12_9 0 10meg
Rh_12_10 g_12_10 g_12_11 100k
Rv_12_10 g_12_10 g_13_10 100k
Rg_12_10 g_12_10 0 10meg
Rh_12_11 g_12_11 g_12_12 100k
Rv_12_11 g_12_11 g_13_11 100k
Rg_12_11 g_12_11 0 10meg
Rh_12_12 g_12_12 g_12_13 100k
Rv_12_12 g_12_12 g_13_12 100k
Rg_12_12 g_12_12 0 10meg
Rh_12_13 g_12_13 g_12_14 100k
Rv_12_13 g_12_13 g_13_13 100k
Rg_12_13 g_12_13 0 10meg
Rh_12_14 g_12_14 g_12_15 100k
Rv_12_14 g_12_14 g_13_14 100k
Rg_12_14 g_12_14 0 10meg
Rh_12_15 g_12_15 g_12_16 100k
Rv_12_15 g_12_15 g_13_15 100k
Rg_12_15 g_12_15 0 10meg
Rh_12_16 g_12_16 g_12_17 100k
Rv_12_16 g_12_16 g_13_16 100k
Rg_12_16 g_12_16 0 10meg
Rh_12_17 g_12_17 g_12_18 100k
Rv_12_17 g_12_17 g_13_17 100k
Rg_12_17 g_12_17 0 10meg
Rh_12_18 g_12_18 g_12_19 100k
Rv_12_18 g_12_18 g_13_18 100k
Rg_12_18 g_12_18 0 10meg
Rv_12_19 g_12_19 g_13_19 100k
Rg_12_19 g_12_19 0 10meg
Rh_13_0 g_13_0 g_13_1 100k
Rg_13_0 g_13_0 0 10meg
Rh_13_1 g_13_1 g_13_2 100k
Rv_13_1 g_13_1 g_14_1 100k
Rg_13_1 g_13_1 0 10meg
Rh_13_2 g_13_2 g_13_3 100k
Rv_13_2 g_13_2 g_14_2 100k
Rg_13_2 g_13_2 0 10meg
Rh_13_3 g_13_3 g_13_4 100k
Rv_13_3 g_13_3 g_14_3 100k
Rg_13_3 g_13_3 0 10meg
Rh_13_4 g_13_4 g_13_5 100k
Rv_13_4 g_13_4 g_14_4 100k
Rg_13_4 g_13_4 0 10meg
Rh_13_5 g_13_5 g_13_6 100k
Rv_13_5 g_13_5 g_14_5 100k
Rg_13_5 g_13_5 0 10meg
Rh_13_6 g_13_6 g_13_7 100k
Rv_13_6 g_13_6 g_14_6 100k
Rg_13_6 g_13_6 0 10meg
Rh_13_7 g_13_7 g_13_8 100k
Rv_13_7 g_13_7 g_14_7 100k
Rg_13_7 g_13_7 0 10meg
Rh_13_8 g_13_8 g_13_9 100k
Rv_13_8 g_13_8 g_14_8 100k
Rg_13_8 g_13_8 0 10meg
Rh_13_9 g_13_9 g_13_10 100k
Rv_13_9 g_13_9 g_14_9 100k
Rg_13_9 g_13_9 0 10meg
Rh_13_10 g_13_10 g_13_11 100k
Rv_13_10 g_13_10 g_14_10 100k
Rg_13_10 g_13_10 0 10meg
Rh_13_11 g_13_11 g_13_12 100k
Rv_13_11 g_13_11 g_14_11 100k
Rg_13_11 g_13_11 0 10meg
Rh_13_12 g_13_12 g_13_13 100k
Rv_13_12 g_13_12 g_14_12 100k
Rg_13_12 g_13_12 0 10meg
Rh_13_13 g_13_13 g_13_14 100k
Rv_13_13 g_13_13 g_14_13 100k
Rg_13_13 g_13_13 0 10meg
Rh_13_14 g_13_14 g_13_15 100k
Rv_13_14 g_13_14 g_14_14 100k
Rg_13_14 g_13_14 0 10meg
Rh_13_15 g_13_15 g_13_16 100k
Rv_13_15 g_13_15 g_14_15 100k
Rg_13_15 g_13_15 0 10meg
Rh_13_16 g_13_16 g_13_17 100k
Rv_13_16 g_13_16 g_14_16 100k
Rg_13_16 g_13_16 0 10meg
Rh_13_17 g_13_17 g_13_18 100k
Rv_13_17 g_13_17 g_14_17 100k
Rg_13_17 g_13_17 0 10meg
Rh_13_18 g_13_18 g_13_19 100k
Rv_13_18 g_13_18 g_14_18 100k
Rg_13_18 g_13_18 0 10meg
Rv_13_19 g_13_19 g_14_19 100k
Rg_13_19 g_13_19 0 10meg
Rh_14_0 g_14_0 g_14_1 100k
Rg_14_0 g_14_0 0 10meg
Rh_14_1 g_14_1 g_14_2 100k
Rv_14_1 g_14_1 g_15_1 100k
Rg_14_1 g_14_1 0 10meg
Rh_14_2 g_14_2 g_14_3 100k
Rv_14_2 g_14_2 g_15_2 100k
Rg_14_2 g_14_2 0 10meg
Rh_14_3 g_14_3 g_14_4 100k
Rv_14_3 g_14_3 g_15_3 100k
Rg_14_3 g_14_3 0 10meg
Rh_14_4 g_14_4 g_14_5 100k
Rv_14_4 g_14_4 g_15_4 100k
Rg_14_4 g_14_4 0 10meg
Rh_14_5 g_14_5 g_14_6 100k
Rv_14_5 g_14_5 g_15_5 100k
Rg_14_5 g_14_5 0 10meg
Rh_14_6 g_14_6 g_14_7 100k
Rv_14_6 g_14_6 g_15_6 100k
Rg_14_6 g_14_6 0 10meg
Rh_14_7 g_14_7 g_14_8 100k
Rv_14_7 g_14_7 g_15_7 100k
Rg_14_7 g_14_7 0 10meg
Rh_14_8 g_14_8 g_14_9 100k
Rv_14_8 g_14_8 g_15_8 100k
Rg_14_8 g_14_8 0 10meg
Rh_14_9 g_14_9 g_14_10 100k
Rv_14_9 g_14_9 g_15_9 100k
Rg_14_9 g_14_9 0 10meg
Rh_14_10 g_14_10 g_14_11 100k
Rv_14_10 g_14_10 g_15_10 100k
Rg_14_10 g_14_10 0 10meg
Rh_14_11 g_14_11 g_14_12 100k
Rv_14_11 g_14_11 g_15_11 100k
Rg_14_11 g_14_11 0 10meg
Rh_14_12 g_14_12 g_14_13 100k
Rv_14_12 g_14_12 g_15_12 100k
Rg_14_12 g_14_12 0 10meg
Rh_14_13 g_14_13 g_14_14 100k
Rv_14_13 g_14_13 g_15_13 100k
Rg_14_13 g_14_13 0 10meg
Rh_14_14 g_14_14 g_14_15 100k
Rv_14_14 g_14_14 g_15_14 100k
Rg_14_14 g_14_14 0 10meg
Rh_14_15 g_14_15 g_14_16 100k
Rv_14_15 g_14_15 g_15_15 100k
Rg_14_15 g_14_15 0 10meg
Rh_14_16 g_14_16 g_14_17 100k
Rv_14_16 g_14_16 g_15_16 100k
Rg_14_16 g_14_16 0 10meg
Rh_14_17 g_14_17 g_14_18 100k
Rv_14_17 g_14_17 g_15_17 100k
Rg_14_17 g_14_17 0 10meg
Rh_14_18 g_14_18 g_14_19 100k
Rv_14_18 g_14_18 g_15_18 100k
Rg_14_18 g_14_18 0 10meg
Rv_14_19 g_14_19 g_15_19 100k
Rg_14_19 g_14_19 0 10meg
Rh_15_0 g_15_0 g_15_1 100k
Rg_15_0 g_15_0 0 10meg
Rh_15_1 g_15_1 g_15_2 100k
Rv_15_1 g_15_1 g_16_1 100k
Rg_15_1 g_15_1 0 10meg
Rh_15_2 g_15_2 g_15_3 100k
Rv_15_2 g_15_2 g_16_2 100k
Rg_15_2 g_15_2 0 10meg
Rh_15_3 g_15_3 g_15_4 100k
Rv_15_3 g_15_3 g_16_3 100k
Rg_15_3 g_15_3 0 10meg
Rh_15_4 g_15_4 g_15_5 100k
Rv_15_4 g_15_4 g_16_4 100k
Rg_15_4 g_15_4 0 10meg
Rh_15_5 g_15_5 g_15_6 100k
Rv_15_5 g_15_5 g_16_5 100k
Rg_15_5 g_15_5 0 10meg
Rh_15_6 g_15_6 g_15_7 100k
Rv_15_6 g_15_6 g_16_6 100k
Rg_15_6 g_15_6 0 10meg
Rh_15_7 g_15_7 g_15_8 100k
Rv_15_7 g_15_7 g_16_7 100k
Rg_15_7 g_15_7 0 10meg
Rh_15_8 g_15_8 g_15_9 100k
Rv_15_8 g_15_8 g_16_8 100k
Rg_15_8 g_15_8 0 10meg
Rh_15_9 g_15_9 g_15_10 100k
Rv_15_9 g_15_9 g_16_9 100k
Rg_15_9 g_15_9 0 10meg
Rh_15_10 g_15_10 g_15_11 100k
Rv_15_10 g_15_10 g_16_10 100k
Rg_15_10 g_15_10 0 10meg
Rh_15_11 g_15_11 g_15_12 100k
Rv_15_11 g_15_11 g_16_11 100k
Rg_15_11 g_15_11 0 10meg
Rh_15_12 g_15_12 g_15_13 100k
Rv_15_12 g_15_12 g_16_12 100k
Rg_15_12 g_15_12 0 10meg
Rh_15_13 g_15_13 g_15_14 100k
Rv_15_13 g_15_13 g_16_13 100k
Rg_15_13 g_15_13 0 10meg
Rh_15_14 g_15_14 g_15_15 100k
Rv_15_14 g_15_14 g_16_14 100k
Rg_15_14 g_15_14 0 10meg
Rh_15_15 g_15_15 g_15_16 100k
Rv_15_15 g_15_15 g_16_15 100k
Rg_15_15 g_15_15 0 10meg
Rh_15_16 g_15_16 g_15_17 100k
Rv_15_16 g_15_16 g_16_16 100k
Rg_15_16 g_15_16 0 10meg
Rh_15_17 g_15_17 g_15_18 100k
Rv_15_17 g_15_17 g_16_17 100k
Rg_15_17 g_15_17 0 10meg
Rh_15_18 g_15_18 g_15_19 100k
Rv_15_18 g_15_18 g_16_18 100k
Rg_15_18 g_15_18 0 10meg
Rv_15_19 g_15_19 g_16_19 100k
Rg_15_19 g_15_19 0 10meg
Rh_16_0 g_16_0 g_16_1 100k
Rg_16_0 g_16_0 0 10meg
Rh_16_1 g_16_1 g_16_2 100k
Rv_16_1 g_16_1 g_17_1 100k
Rg_16_1 g_16_1 0 10meg
Rh_16_2 g_16_2 g_16_3 100k
Rv_16_2 g_16_2 g_17_2 100k
Rg_16_2 g_16_2 0 10meg
Rh_16_3 g_16_3 g_16_4 100k
Rv_16_3 g_16_3 g_17_3 100k
Rg_16_3 g_16_3 0 10meg
Rh_16_4 g_16_4 g_16_5 100k
Rv_16_4 g_16_4 g_17_4 100k
Rg_16_4 g_16_4 0 10meg
Rh_16_5 g_16_5 g_16_6 100k
Rv_16_5 g_16_5 g_17_5 100k
Rg_16_5 g_16_5 0 10meg
Rh_16_6 g_16_6 g_16_7 100k
Rv_16_6 g_16_6 g_17_6 100k
Rg_16_6 g_16_6 0 10meg
Rh_16_7 g_16_7 g_16_8 100k
Rv_16_7 g_16_7 g_17_7 100k
Rg_16_7 g_16_7 0 10meg
Rh_16_8 g_16_8 g_16_9 100k
Rv_16_8 g_16_8 g_17_8 100k
Rg_16_8 g_16_8 0 10meg
Rh_16_9 g_16_9 g_16_10 100k
Rv_16_9 g_16_9 g_17_9 100k
Rg_16_9 g_16_9 0 10meg
Rh_16_10 g_16_10 g_16_11 100k
Rv_16_10 g_16_10 g_17_10 100k
Rg_16_10 g_16_10 0 10meg
Rh_16_11 g_16_11 g_16_12 100k
Rv_16_11 g_16_11 g_17_11 100k
Rg_16_11 g_16_11 0 10meg
Rh_16_12 g_16_12 g_16_13 100k
Rv_16_12 g_16_12 g_17_12 100k
Rg_16_12 g_16_12 0 10meg
Rh_16_13 g_16_13 g_16_14 100k
Rv_16_13 g_16_13 g_17_13 100k
Rg_16_13 g_16_13 0 10meg
Rh_16_14 g_16_14 g_16_15 100k
Rv_16_14 g_16_14 g_17_14 100k
Rg_16_14 g_16_14 0 10meg
Rh_16_15 g_16_15 g_16_16 100k
Rv_16_15 g_16_15 g_17_15 100k
Rg_16_15 g_16_15 0 10meg
Rh_16_16 g_16_16 g_16_17 100k
Rv_16_16 g_16_16 g_17_16 100k
Rg_16_16 g_16_16 0 10meg
Rh_16_17 g_16_17 g_16_18 100k
Rv_16_17 g_16_17 g_17_17 100k
Rg_16_17 g_16_17 0 10meg
Rh_16_18 g_16_18 g_16_19 100k
Rv_16_18 g_16_18 g_17_18 100k
Rg_16_18 g_16_18 0 10meg
Rv_16_19 g_16_19 g_17_19 100k
Rg_16_19 g_16_19 0 10meg
Rh_17_0 g_17_0 g_17_1 100k
Rg_17_0 g_17_0 0 10meg
Rh_17_1 g_17_1 g_17_2 100k
Rv_17_1 g_17_1 g_18_1 100k
Rg_17_1 g_17_1 0 10meg
Rh_17_2 g_17_2 g_17_3 100k
Rv_17_2 g_17_2 g_18_2 100k
Rg_17_2 g_17_2 0 10meg
Rh_17_3 g_17_3 g_17_4 100k
Rv_17_3 g_17_3 g_18_3 100k
Rg_17_3 g_17_3 0 10meg
Rh_17_4 g_17_4 g_17_5 100k
Rv_17_4 g_17_4 g_18_4 100k
Rg_17_4 g_17_4 0 10meg
Rh_17_5 g_17_5 g_17_6 100k
Rv_17_5 g_17_5 g_18_5 100k
Rg_17_5 g_17_5 0 10meg
Rh_17_6 g_17_6 g_17_7 100k
Rv_17_6 g_17_6 g_18_6 100k
Rg_17_6 g_17_6 0 10meg
Rh_17_7 g_17_7 g_17_8 100k
Rv_17_7 g_17_7 g_18_7 100k
Rg_17_7 g_17_7 0 10meg
Rh_17_8 g_17_8 g_17_9 100k
Rv_17_8 g_17_8 g_18_8 100k
Rg_17_8 g_17_8 0 10meg
Rh_17_9 g_17_9 g_17_10 100k
Rv_17_9 g_17_9 g_18_9 100k
Rg_17_9 g_17_9 0 10meg
Rh_17_10 g_17_10 g_17_11 100k
Rv_17_10 g_17_10 g_18_10 100k
Rg_17_10 g_17_10 0 10meg
Rh_17_11 g_17_11 g_17_12 100k
Rv_17_11 g_17_11 g_18_11 100k
Rg_17_11 g_17_11 0 10meg
Rh_17_12 g_17_12 g_17_13 100k
Rv_17_12 g_17_12 g_18_12 100k
Rg_17_12 g_17_12 0 10meg
Rh_17_13 g_17_13 g_17_14 100k
Rv_17_13 g_17_13 g_18_13 100k
Rg_17_13 g_17_13 0 10meg
Rh_17_14 g_17_14 g_17_15 100k
Rv_17_14 g_17_14 g_18_14 100k
Rg_17_14 g_17_14 0 10meg
Rh_17_15 g_17_15 g_17_16 100k
Rv_17_15 g_17_15 g_18_15 100k
Rg_17_15 g_17_15 0 10meg
Rh_17_16 g_17_16 g_17_17 100k
Rv_17_16 g_17_16 g_18_16 100k
Rg_17_16 g_17_16 0 10meg
Rh_17_17 g_17_17 g_17_18 100k
Rv_17_17 g_17_17 g_18_17 100k
Rg_17_17 g_17_17 0 10meg
Rh_17_18 g_17_18 g_17_19 100k
Rv_17_18 g_17_18 g_18_18 100k
Rg_17_18 g_17_18 0 10meg
Rv_17_19 g_17_19 g_18_19 100k
Rg_17_19 g_17_19 0 10meg
Rh_18_0 g_18_0 g_18_1 100k
Rg_18_0 g_18_0 0 10meg
Rh_18_1 g_18_1 g_18_2 100k
Rv_18_1 g_18_1 g_19_1 100k
Rg_18_1 g_18_1 0 10meg
Rh_18_2 g_18_2 g_18_3 100k
Rv_18_2 g_18_2 g_19_2 100k
Rg_18_2 g_18_2 0 10meg
Rh_18_3 g_18_3 g_18_4 100k
Rv_18_3 g_18_3 g_19_3 100k
Rg_18_3 g_18_3 0 10meg
Rh_18_4 g_18_4 g_18_5 100k
Rv_18_4 g_18_4 g_19_4 100k
Rg_18_4 g_18_4 0 10meg
Rh_18_5 g_18_5 g_18_6 100k
Rv_18_5 g_18_5 g_19_5 100k
Rg_18_5 g_18_5 0 10meg
Rh_18_6 g_18_6 g_18_7 100k
Rv_18_6 g_18_6 g_19_6 100k
Rg_18_6 g_18_6 0 10meg
Rh_18_7 g_18_7 g_18_8 100k
Rv_18_7 g_18_7 g_19_7 100k
Rg_18_7 g_18_7 0 10meg
Rh_18_8 g_18_8 g_18_9 100k
Rv_18_8 g_18_8 g_19_8 100k
Rg_18_8 g_18_8 0 10meg
Rh_18_9 g_18_9 g_18_10 100k
Rv_18_9 g_18_9 g_19_9 100k
Rg_18_9 g_18_9 0 10meg
Rh_18_10 g_18_10 g_18_11 100k
Rv_18_10 g_18_10 g_19_10 100k
Rg_18_10 g_18_10 0 10meg
Rh_18_11 g_18_11 g_18_12 100k
Rv_18_11 g_18_11 g_19_11 100k
Rg_18_11 g_18_11 0 10meg
Rh_18_12 g_18_12 g_18_13 100k
Rv_18_12 g_18_12 g_19_12 100k
Rg_18_12 g_18_12 0 10meg
Rh_18_13 g_18_13 g_18_14 100k
Rv_18_13 g_18_13 g_19_13 100k
Rg_18_13 g_18_13 0 10meg
Rh_18_14 g_18_14 g_18_15 100k
Rv_18_14 g_18_14 g_19_14 100k
Rg_18_14 g_18_14 0 10meg
Rh_18_15 g_18_15 g_18_16 100k
Rv_18_15 g_18_15 g_19_15 100k
Rg_18_15 g_18_15 0 10meg
Rh_18_16 g_18_16 g_18_17 100k
Rv_18_16 g_18_16 g_19_16 100k
Rg_18_16 g_18_16 0 10meg
Rh_18_17 g_18_17 g_18_18 100k
Rv_18_17 g_18_17 g_19_17 100k
Rg_18_17 g_18_17 0 10meg
Rh_18_18 g_18_18 g_18_19 100k
Rv_18_18 g_18_18 g_19_18 100k
Rg_18_18 g_18_18 0 10meg
Rv_18_19 g_18_19 g_19_19 100k
Rg_18_19 g_18_19 0 10meg
Rh_19_0 g_19_0 g_19_1 100k
Rg_19_0 g_19_0 0 10meg
Rh_19_1 g_19_1 g_19_2 100k
Rg_19_1 g_19_1 0 10meg
Rh_19_2 g_19_2 g_19_3 100k
Rg_19_2 g_19_2 0 10meg
Rh_19_3 g_19_3 g_19_4 100k
Rg_19_3 g_19_3 0 10meg
Rh_19_4 g_19_4 g_19_5 100k
Rg_19_4 g_19_4 0 10meg
Rh_19_5 g_19_5 g_19_6 100k
Rg_19_5 g_19_5 0 10meg
Rh_19_6 g_19_6 g_19_7 100k
Rg_19_6 g_19_6 0 10meg
Rh_19_7 g_19_7 g_19_8 100k
Rg_19_7 g_19_7 0 10meg
Rh_19_8 g_19_8 g_19_9 100k
Rg_19_8 g_19_8 0 10meg
Rh_19_9 g_19_9 g_19_10 100k
Rg_19_9 g_19_9 0 10meg
Rh_19_10 g_19_10 g_19_11 100k
Rg_19_10 g_19_10 0 10meg
Rh_19_11 g_19_11 g_19_12 100k
Rg_19_11 g_19_11 0 10meg
Rh_19_12 g_19_12 g_19_13 100k
Rg_19_12 g_19_12 0 10meg
Rh_19_13 g_19_13 g_19_14 100k
Rg_19_13 g_19_13 0 10meg
Rh_19_14 g_19_14 g_19_15 100k
Rg_19_14 g_19_14 0 10meg
Rh_19_15 g_19_15 g_19_16 100k
Rg_19_15 g_19_15 0 10meg
Rh_19_16 g_19_16 g_19_17 100k
Rg_19_16 g_19_16 0 10meg
Rh_19_17 g_19_17 g_19_18 100k
Rg_19_17 g_19_17 0 10meg
Rh_19_18 g_19_18 g_19_19 100k
Rg_19_18 g_19_18 0 10meg
Rg_19_19 g_19_19 0 10meg
Vin in 0 DC 1.0
.dc Vin -1 1 0.02
.control
  pre_osdi /Users/meisam/software-builds/version2/absdelay_examples/absdelay.osdi
  run
.endc
.end
